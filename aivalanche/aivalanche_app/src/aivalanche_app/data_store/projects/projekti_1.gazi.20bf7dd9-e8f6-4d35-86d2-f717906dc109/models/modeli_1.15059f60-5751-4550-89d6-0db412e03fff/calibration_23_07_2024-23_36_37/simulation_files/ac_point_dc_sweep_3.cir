**********************************************************
* THIS FILE IS GENERATED BY AIVALANCHE
* FILE ID: 3
* SIMULATION TYPE: ac_point_dc_sweep
**********************************************************

* Define the temperature
.TEMP 25.0

* Include the dut file
.INCLUDE /home/gazi/Desktop/Work/custom_packages/aivalanche/aivalanche_app/src/aivalanche_app/data_store/projects/projekti_1.gazi.20bf7dd9-e8f6-4d35-86d2-f717906dc109/common/model_files/dut_1.cir

** Start testbenches

********************* dut testbench 20_0 *********************
v_gs_ac_20_0 g_20_0 g_ac_20_0 DC 0 AC 1
e_gs_20_0 g_ac_20_0 0 v_sweep 0 1
v_ds_20_0 d_20_0 0 0.0
v_s_20_0 s_20_0 0 0
v_bs_20_0 b_20_0 0 0.0
x_20_0 d_20_0 g_20_0 s_20_0 b_20_0 dut w=5e-06 l=6e-06 m=1.0
*************************************************************

********************* dut testbench 20_1 *********************
v_gs_ac_20_1 g_20_1 g_ac_20_1 DC 0 AC 1
e_gs_20_1 g_ac_20_1 0 v_sweep 0 1
v_ds_20_1 d_20_1 0 0.0
v_s_20_1 s_20_1 0 0
v_bs_20_1 b_20_1 0 1.0
x_20_1 d_20_1 g_20_1 s_20_1 b_20_1 dut w=5e-06 l=6e-06 m=1.0
*************************************************************

********************* dut testbench 20_2 *********************
v_gs_ac_20_2 g_20_2 g_ac_20_2 DC 0 AC 1
e_gs_20_2 g_ac_20_2 0 v_sweep 0 1
v_ds_20_2 d_20_2 0 0.0
v_s_20_2 s_20_2 0 0
v_bs_20_2 b_20_2 0 -1.0
x_20_2 d_20_2 g_20_2 s_20_2 b_20_2 dut w=5e-06 l=6e-06 m=1.0
*************************************************************

** End testbenches

* Declare the v_sweep, which will change during the simulation.
v_sweep v_sweep 0 0

********** Start of control section **********
.control

** Model parameters start
alterparam dut a0 = 2.8892724532804515
alterparam dut a1 = 0.0414120048583886
alterparam dut a2 = 0.4594089562483875
alterparam dut acde = 0.9774255928900465
alterparam dut ags = 1.171895681202121
alterparam dut cf = 1.1736579500936869e-10
alterparam dut cgdl = 4.637492510520945e-10
alterparam dut cgdo = 1.3709738521173764e-10
alterparam dut ckappas = 13.860915474523619
alterparam dut clc = 1.2255312981764727e-07
alterparam dut cle = 0.45465745520017997
alterparam dut dlc = 1*-2.8479922401627696e-10
alterparam dut drout = 1.5639245161642594
alterparam dut dsub = 0.6504504348877233
alterparam dut dvt0 = 12.877748161783575
alterparam dut dvt0w = 1.4528243796939222
alterparam dut dvt1 = 1.0663680824218542
alterparam dut dvt1w = 42037.466682701124
alterparam dut dvt2 = 1*-0.013723826179623227
alterparam dut dvt2w = 1*-0.037742386577257536
alterparam dut dwg = 7.98305191712238e-08
alterparam dut eta0 = 0.6457044010038512
alterparam dut etab = 1*-0.4007008131283848
alterparam dut k1 = 1.0798089438807756
alterparam dut k2 = 0.02126868272605857
alterparam dut k3 = 95.54389472935523
alterparam dut k3b = 20.754943312617044
alterparam dut keta = 1*-0.04103655940348602
alterparam dut lint = 1*-8.332881135926349e-08
alterparam dut ll = 5.574247445549194e-14
alterparam dut moin = 14.152526203393588
alterparam dut ndep = 1.8640816671384492e+16
alterparam dut nfactor = 0.5177556366782479
alterparam dut ngate = 4.226632794587848e+22
alterparam dut noff = 3.830132045537072
alterparam dut pclm = 0.00011042578710985436
alterparam dut pdiblc1 = 0.009038335684788323
alterparam dut pdiblc2 = 0.00010736161008552799
alterparam dut pdiblcb = 1*-0.22041136498965352
alterparam dut pvag = 3.6048962411676833
alterparam dut rdsw = 576.9374572821034
alterparam dut toxp = 6.811639724333487e-09
alterparam dut u0 = 364.27289740482985
alterparam dut ua = 1*-4.280901527593855e-09
alterparam dut ub = 4.2356182847531465e-21
alterparam dut uc = 1.397792863883442e-09
alterparam dut voff = 1*-0.13487652955091622
alterparam dut voffcv = 0.10223062961014151
alterparam dut vsat = 96957.51940594205
alterparam dut vth0 = 0.7869169346123672
alterparam dut w0 = 1.0732364902367269e-09
alterparam dut wint = 4.019828529575561e-08
alterparam dut ww = 1*-4.2803866448543726e-14
alterparam dut wwl = 3.1270448980587557e-20
alterparam dut lwl = 1*-7.861265427053483e-20
alterparam dut voffl = 1*-9.423921344654913e-08
alterparam dut xpart = 0.41688417321440674
alterparam dut bin_pvsat = 0.5093197533374378
alterparam dut bin_prdsw = 0.5868414831177307
alterparam dut bin_ppclm = 0.5089187935354991
alterparam dut bin_wketa = 0.6914020245883808
alterparam dut bin_lketa = 0.8167036812567698
alterparam dut bin_pketa = 0.1657720468036764
alterparam dut bin_wk3 = 0.7325299839407886
alterparam dut bin_wk3b = 0.9057191004924546
reset
** Model parameters end

** Declare the vectors to save.
save i(v_ds_20_2) i(v_ds_20_1) i(v_ds_20_0)

** Write the header of the results file.
echo "vgs,cgd_20_1,cgd_20_2,cgd_20_0" > /home/gazi/Desktop/Work/custom_packages/aivalanche/aivalanche_app/src/aivalanche_app/data_store/projects/projekti_1.gazi.20bf7dd9-e8f6-4d35-86d2-f717906dc109/models/modeli_1.15059f60-5751-4550-89d6-0db412e03fff/calibration_23_07_2024-23_36_37/simulation_files/ac_point_dc_sweep_3.csv

** Start the simulation loop.
compose values_list start=-2.0 stop=2.0 step=0.05
foreach val $&values_list
    alter v_sweep $val
    ac lin 1 10000.0 10000.0

    let cgd_20_0 = abs(imag(i(v_ds_20_0)))/2*pi*10000.0
    let cgd_20_1 = abs(imag(i(v_ds_20_1)))/2*pi*10000.0
    let cgd_20_2 = abs(imag(i(v_ds_20_2)))/2*pi*10000.0

    echo "$val,$&cgd_20_1,$&cgd_20_2,$&cgd_20_0" >> /home/gazi/Desktop/Work/custom_packages/aivalanche/aivalanche_app/src/aivalanche_app/data_store/projects/projekti_1.gazi.20bf7dd9-e8f6-4d35-86d2-f717906dc109/models/modeli_1.15059f60-5751-4550-89d6-0db412e03fff/calibration_23_07_2024-23_36_37/simulation_files/ac_point_dc_sweep_3.csv
end

.endc
********** End of control section **********

.end
