**********************************************************
* THIS FILE IS GENERATED BY AIVALANCHE
* FILE ID: 0
* SIMULATION TYPE: ac_point_dc_list
**********************************************************

* Define the temperature
.TEMP 25.0

* Include the dut file
.INCLUDE /home/gazi/Desktop/Work/custom_packages/aivalanche/aivalanche_app/src/aivalanche_app/data_store/projects/projekti_1.gazi.20bf7dd9-e8f6-4d35-86d2-f717906dc109/common/model_files/dut_1.cir

** Start testbenches

********************* dut testbench 21_1 *********************
v_gs_ac_21_1 g_21_1 g_ac_21_1 DC 0 AC 1
e_gs_21_1 g_ac_21_1 0 v_sweep 0 1
v_ds_21_1 d_21_1 0 0.0
v_s_21_1 s_21_1 0 0
v_bs_21_1 b_21_1 0 1.0
x_21_1 d_21_1 g_21_1 s_21_1 b_21_1 dut w=5e-06 l=6e-06 m=1.0
*************************************************************

** End testbenches

* Declare the v_sweep, which will change during the simulation.
v_sweep v_sweep 0 0

********** Start of control section **********
.control

** Model parameters start
alterparam dut a0 = 1.203706220711176
alterparam dut a1 = 0.00038898024351961884
alterparam dut a2 = 0.7139126056018589
alterparam dut acde = 1.2964922636713132
alterparam dut ags = 0.6670928290274252
alterparam dut cf = 8.143743944695933e-11
alterparam dut cgdl = 2.664205234259324e-10
alterparam dut cgdo = 8.241222241862589e-11
alterparam dut ckappas = 16.725792932755443
alterparam dut clc = 6.68022992166883e-08
alterparam dut cle = 0.25886470936170375
alterparam dut dlc = 1*-3.8114326236308876e-08
alterparam dut drout = 1.5115853763632179
alterparam dut dsub = 0.38266799700865006
alterparam dut dvt0 = 7.1028298398511165
alterparam dut dvt0w = 3.7951504258809505
alterparam dut dvt1 = 0.485055053024562
alterparam dut dvt1w = 5837099.602738459
alterparam dut dvt2 = 0.08538684506021951
alterparam dut dvt2w = 1*-0.03517052037038613
alterparam dut dwg = 1.3527808985974811e-08
alterparam dut eta0 = 0.8901377403666022
alterparam dut etab = 1*-0.020588107870783245
alterparam dut k1 = 0.8440299919871135
alterparam dut k2 = 1*-0.027529597408201368
alterparam dut k3 = 1*-44.84910427860477
alterparam dut k3b = 7.872921028433609
alterparam dut keta = 1*-0.06115397680997847
alterparam dut lint = 1*-6.6475790809183834e-09
alterparam dut ll = 2.9783152165569636e-14
alterparam dut moin = 22.902083558198246
alterparam dut ndep = 1.890788253921401e+16
alterparam dut nfactor = 0.4315621460719962
alterparam dut ngate = 4.4440972225150996e+20
alterparam dut noff = 0.7949145979279937
alterparam dut pclm = 2.3585162343818086e-08
alterparam dut pdiblc1 = 0.006133204035604043
alterparam dut pdiblc2 = 0.0011246522592156041
alterparam dut pdiblcb = 0.24696903297981643
alterparam dut pvag = 0.6868067360576675
alterparam dut rdsw = 1923.3341734390938
alterparam dut toxp = 7.054118255745744e-09
alterparam dut u0 = 165.56598779632733
alterparam dut ua = 1*-5.988706370738608e-09
alterparam dut ub = 8.570760491462703e-18
alterparam dut uc = 7.926212382140693e-09
alterparam dut voff = 1*-0.07656157902187936
alterparam dut voffcv = 0.1210276752552879
alterparam dut vsat = 8257.515915442622
alterparam dut vth0 = 1.9511139866975133
alterparam dut w0 = 1.1153298562399871e-10
alterparam dut wint = 1.3198961950612733e-07
alterparam dut ww = 1*-6.623587526653153e-14
alterparam dut wwl = 4.9706497757665374e-21
alterparam dut lwl = 1*-8.622100003065355e-20
alterparam dut voffl = 1*-8.668471053839372e-08
alterparam dut xpart = 0.2455956486773232
alterparam dut bin_pvsat = 0.6192499485490434
alterparam dut bin_prdsw = 0.6924713610182139
alterparam dut bin_ppclm = 0.47543400749183046
alterparam dut bin_wketa = 0.8064884120160516
alterparam dut bin_lketa = 0.3044687079448468
alterparam dut bin_pketa = 0.6944231085763221
alterparam dut bin_wk3 = 0.6448001219344437
alterparam dut bin_wk3b = 0.4937570335750299
reset
** Model parameters end

** Declare the vectors to save.
save i(v_s_21_1)

** Write the header of the results file.
echo "vgs,cgs_21_1" > /home/gazi/Desktop/Work/custom_packages/aivalanche/aivalanche_app/src/aivalanche_app/data_store/projects/projekti_1.gazi.20bf7dd9-e8f6-4d35-86d2-f717906dc109/models/modeli_1.15059f60-5751-4550-89d6-0db412e03fff/calibration_23_07_2024-23_06_55/simulation_files/ac_point_dc_list_0.csv

** Start the simulation loop.
set values_list = ( -2.0 -1.95 -1.8 -1.75 -1.7 -1.65 -1.6 -1.55 -1.5 -1.45 -1.4 -1.35 -1.3 -1.25 -1.2 -1.15 -1.1 -1.05 -1.0 -0.95 -0.9 -0.85 -0.8 -0.75 -0.7 -0.65 -0.6 -0.55 -0.5 -0.45 -0.4 -0.35 -0.3 -0.25 -0.2 -0.15 -0.1 -0.05 1.20737e-15 0.05 0.1 0.15 0.2 0.25 0.3 0.35 0.4 0.45 0.5 0.55 0.6 0.65 0.7 0.75 0.8 0.85 0.9 0.95 1.0 1.05 1.1 1.15 1.2 1.25 1.3 1.35 1.4 1.45 1.5 1.55 1.6 1.65 1.7 1.75 1.8 1.85 1.9 1.95 2.0 )
foreach val $values_list
    alter v_sweep $val
    ac lin 1 10000.0 10000.0

    let cgs_21_1 = abs(imag(i(v_s_21_1)))/2*pi*10000.0

    echo "$val,$&cgs_21_1" >> /home/gazi/Desktop/Work/custom_packages/aivalanche/aivalanche_app/src/aivalanche_app/data_store/projects/projekti_1.gazi.20bf7dd9-e8f6-4d35-86d2-f717906dc109/models/modeli_1.15059f60-5751-4550-89d6-0db412e03fff/calibration_23_07_2024-23_06_55/simulation_files/ac_point_dc_list_0.csv
end

.endc
********** End of control section **********

.end
