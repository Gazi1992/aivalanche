**********************************************************
* THIS FILE IS GENERATED BY AIVALANCHE
* FILE ID: 8
* SIMULATION TYPE: dc_list
**********************************************************

* Define the temperature
.TEMP 25.0

* Include the dut file
.INCLUDE /home/gazi/Desktop/Work/custom_packages/aivalanche/aivalanche_app/src/aivalanche_app/data_store/projects/projekti_1.gazi.20bf7dd9-e8f6-4d35-86d2-f717906dc109/common/model_files/dut_1.cir

** Start testbenches

********************* dut testbench 1_4 *********************
e_ds_1_4 d_1_4 0 v_sweep 0 1
v_gs_1_4 g_1_4 0 1.0
v_s_1_4 s_1_4 0 0
v_bs_1_4 b_1_4 0 0.0
x_1_4 d_1_4 g_1_4 s_1_4 b_1_4 dut w=1e-05 l=1e-05 m=1.0
*************************************************************

** End testbenches

* Declare the v_sweep, which will change during the simulation.
v_sweep v_sweep 0 0

********** Start of control section **********
.control

** Model parameters start
alterparam dut a0 = 0.7207169082419732
alterparam dut a1 = 0.037703457524796674
alterparam dut a2 = 0.9625848983645664
alterparam dut acde = 0.6614638448296188
alterparam dut ags = 0.03494866935372952
alterparam dut cf = 6.846799384322189e-11
alterparam dut cgdl = 8.756401670154964e-10
alterparam dut cgdo = 1.4072800574244665e-10
alterparam dut ckappas = 12.171002123044989
alterparam dut clc = 5.089822062185611e-08
alterparam dut cle = 0.9030880143541664
alterparam dut dlc = 1*-2.3934526352561725e-08
alterparam dut drout = 1.960786213910068
alterparam dut dsub = 0.6549965900453213
alterparam dut dvt0 = 19.857580181639044
alterparam dut dvt0w = 1*-0.5393905570327244
alterparam dut dvt1 = 0.852267063068417
alterparam dut dvt1w = 1.404744184602075
alterparam dut dvt2 = 0.06533654155115404
alterparam dut dvt2w = 1*-0.0026349657561453924
alterparam dut dwg = 9.292232457032572e-08
alterparam dut eta0 = 0.7151203132259272
alterparam dut etab = 1*-0.10973856540498506
alterparam dut k1 = 0.6704368093650003
alterparam dut k2 = 0.013297231041782459
alterparam dut k3 = 21.778370039656522
alterparam dut k3b = 1*-22.51667349984081
alterparam dut keta = 1*-0.02391678482080263
alterparam dut lint = 1*-7.711571344078094e-08
alterparam dut ll = 4.327999153410291e-14
alterparam dut moin = 16.209480100306834
alterparam dut ndep = 2.1579596122966538e+17
alterparam dut nfactor = 0.02316045676339766
alterparam dut ngate = 1.777381853902339e+20
alterparam dut noff = 1.4274313981831874
alterparam dut pclm = 0.011341835663803812
alterparam dut pdiblc1 = 0.11907439903696582
alterparam dut pdiblc2 = 0.0059069589589532245
alterparam dut pdiblcb = 1*-0.05702564902006135
alterparam dut pvag = 3.9344161251435743
alterparam dut rdsw = 2309.761765593733
alterparam dut toxp = 4.5690009188801085e-09
alterparam dut u0 = 222.09045190746957
alterparam dut ua = 1*-6.197017100028607e-09
alterparam dut ub = 1.1175212395434084e-19
alterparam dut uc = 6.4011291931475104e-09
alterparam dut voff = 1*-0.010400401940760945
alterparam dut voffcv = 1*-0.3233372393272789
alterparam dut vsat = 38949.114090803334
alterparam dut vth0 = 1.9670199539540025
alterparam dut w0 = 5.905089354350037e-07
alterparam dut wint = 1*-7.943385543934449e-08
alterparam dut ww = 1*-5.74521464250137e-14
alterparam dut wwl = 1*-5.796222090687993e-21
alterparam dut lwl = 1*-6.4630819691324e-20
alterparam dut voffl = 1*-8.291146828043814e-08
alterparam dut xpart = 0.16989620186950616
alterparam dut bin_pvsat = 0.43459718423785093
alterparam dut bin_prdsw = 0.6030147757669637
alterparam dut bin_ppclm = 0.2088839670588994
alterparam dut bin_wketa = 0.8423732752967394
alterparam dut bin_lketa = 0.47900956460767485
alterparam dut bin_pketa = 0.5083321348410523
alterparam dut bin_wk3 = 0.6138294949665571
alterparam dut bin_wk3b = 0.31314818292575325
reset
** Model parameters end

** Declare the vectors to save.
save i(v_s_1_4) v(d_1_4)

** Write the header of the results file.
echo "i(v_s_1_4),v(d_1_4)" > /home/gazi/Desktop/Work/custom_packages/aivalanche/aivalanche_app/src/aivalanche_app/data_store/projects/projekti_1.gazi.20bf7dd9-e8f6-4d35-86d2-f717906dc109/models/modeli_1.15059f60-5751-4550-89d6-0db412e03fff/calibration_23_07_2024-22_49_01/simulation_files/dc_list_8.csv

** Start the simulation loop.
set values_list = ( 0.0 0.2 0.3 0.4 0.5 0.6 0.7 0.8 0.9 1.0 1.1 1.2 1.3 1.4 1.5 1.6 )
foreach val $values_list
    alter v_sweep $val
    op
    echo "$&i(v_s_1_4),$&v(d_1_4)" >> /home/gazi/Desktop/Work/custom_packages/aivalanche/aivalanche_app/src/aivalanche_app/data_store/projects/projekti_1.gazi.20bf7dd9-e8f6-4d35-86d2-f717906dc109/models/modeli_1.15059f60-5751-4550-89d6-0db412e03fff/calibration_23_07_2024-22_49_01/simulation_files/dc_list_8.csv
end

.endc
********** End of control section **********

.end
