**********************************************************
* THIS FILE IS GENERATED BY AIVALANCHE
* FILE ID: 9
* SIMULATION TYPE: dc_sweep
**********************************************************

* Define the temperature
.TEMP 25.0

* Include the dut file
.INCLUDE /home/gazi/Desktop/Work/custom_packages/aivalanche/aivalanche_app/src/aivalanche_app/data_store/projects/projekti_1.gazi.20bf7dd9-e8f6-4d35-86d2-f717906dc109/common/model_files/dut_1.cir

** Start testbenches

********************* dut testbench 10_0 *********************
v_ds_10_0 d_10_0 0 0.05
e_gs_10_0 g_10_0 0 v_sweep 0 1
v_s_10_0 s_10_0 0 0
v_bs_10_0 b_10_0 0 -1.0
x_10_0 d_10_0 g_10_0 s_10_0 b_10_0 dut w=1e-05 l=1e-05 m=1.0
*************************************************************

********************* dut testbench 10_1 *********************
v_ds_10_1 d_10_1 0 0.05
e_gs_10_1 g_10_1 0 v_sweep 0 1
v_s_10_1 s_10_1 0 0
v_bs_10_1 b_10_1 0 -0.75
x_10_1 d_10_1 g_10_1 s_10_1 b_10_1 dut w=1e-05 l=1e-05 m=1.0
*************************************************************

********************* dut testbench 10_2 *********************
v_ds_10_2 d_10_2 0 0.05
e_gs_10_2 g_10_2 0 v_sweep 0 1
v_s_10_2 s_10_2 0 0
v_bs_10_2 b_10_2 0 -0.5
x_10_2 d_10_2 g_10_2 s_10_2 b_10_2 dut w=1e-05 l=1e-05 m=1.0
*************************************************************

********************* dut testbench 10_3 *********************
v_ds_10_3 d_10_3 0 0.05
e_gs_10_3 g_10_3 0 v_sweep 0 1
v_s_10_3 s_10_3 0 0
v_bs_10_3 b_10_3 0 -0.25
x_10_3 d_10_3 g_10_3 s_10_3 b_10_3 dut w=1e-05 l=1e-05 m=1.0
*************************************************************

********************* dut testbench 10_4 *********************
v_ds_10_4 d_10_4 0 0.05
e_gs_10_4 g_10_4 0 v_sweep 0 1
v_s_10_4 s_10_4 0 0
v_bs_10_4 b_10_4 0 0.0
x_10_4 d_10_4 g_10_4 s_10_4 b_10_4 dut w=1e-05 l=1e-05 m=1.0
*************************************************************

********************* dut testbench 11_0 *********************
v_ds_11_0 d_11_0 0 1.6
e_gs_11_0 g_11_0 0 v_sweep 0 1
v_s_11_0 s_11_0 0 0
v_bs_11_0 b_11_0 0 -1.0
x_11_0 d_11_0 g_11_0 s_11_0 b_11_0 dut w=1e-05 l=1e-05 m=1.0
*************************************************************

********************* dut testbench 11_1 *********************
v_ds_11_1 d_11_1 0 1.6
e_gs_11_1 g_11_1 0 v_sweep 0 1
v_s_11_1 s_11_1 0 0
v_bs_11_1 b_11_1 0 -0.75
x_11_1 d_11_1 g_11_1 s_11_1 b_11_1 dut w=1e-05 l=1e-05 m=1.0
*************************************************************

********************* dut testbench 11_2 *********************
v_ds_11_2 d_11_2 0 1.6
e_gs_11_2 g_11_2 0 v_sweep 0 1
v_s_11_2 s_11_2 0 0
v_bs_11_2 b_11_2 0 -0.5
x_11_2 d_11_2 g_11_2 s_11_2 b_11_2 dut w=1e-05 l=1e-05 m=1.0
*************************************************************

********************* dut testbench 11_3 *********************
v_ds_11_3 d_11_3 0 1.6
e_gs_11_3 g_11_3 0 v_sweep 0 1
v_s_11_3 s_11_3 0 0
v_bs_11_3 b_11_3 0 -0.25
x_11_3 d_11_3 g_11_3 s_11_3 b_11_3 dut w=1e-05 l=1e-05 m=1.0
*************************************************************

********************* dut testbench 11_4 *********************
v_ds_11_4 d_11_4 0 1.6
e_gs_11_4 g_11_4 0 v_sweep 0 1
v_s_11_4 s_11_4 0 0
v_bs_11_4 b_11_4 0 0.0
x_11_4 d_11_4 g_11_4 s_11_4 b_11_4 dut w=1e-05 l=1e-05 m=1.0
*************************************************************

********************* dut testbench 12_0 *********************
v_ds_12_0 d_12_0 0 0.05
e_gs_12_0 g_12_0 0 v_sweep 0 1
v_s_12_0 s_12_0 0 0
v_bs_12_0 b_12_0 0 -1.0
x_12_0 d_12_0 g_12_0 s_12_0 b_12_0 dut w=5e-06 l=5e-06 m=1.0
*************************************************************

********************* dut testbench 12_1 *********************
v_ds_12_1 d_12_1 0 0.05
e_gs_12_1 g_12_1 0 v_sweep 0 1
v_s_12_1 s_12_1 0 0
v_bs_12_1 b_12_1 0 -0.75
x_12_1 d_12_1 g_12_1 s_12_1 b_12_1 dut w=5e-06 l=5e-06 m=1.0
*************************************************************

********************* dut testbench 12_2 *********************
v_ds_12_2 d_12_2 0 0.05
e_gs_12_2 g_12_2 0 v_sweep 0 1
v_s_12_2 s_12_2 0 0
v_bs_12_2 b_12_2 0 -0.5
x_12_2 d_12_2 g_12_2 s_12_2 b_12_2 dut w=5e-06 l=5e-06 m=1.0
*************************************************************

********************* dut testbench 12_3 *********************
v_ds_12_3 d_12_3 0 0.05
e_gs_12_3 g_12_3 0 v_sweep 0 1
v_s_12_3 s_12_3 0 0
v_bs_12_3 b_12_3 0 -0.25
x_12_3 d_12_3 g_12_3 s_12_3 b_12_3 dut w=5e-06 l=5e-06 m=1.0
*************************************************************

********************* dut testbench 12_4 *********************
v_ds_12_4 d_12_4 0 0.05
e_gs_12_4 g_12_4 0 v_sweep 0 1
v_s_12_4 s_12_4 0 0
v_bs_12_4 b_12_4 0 0.0
x_12_4 d_12_4 g_12_4 s_12_4 b_12_4 dut w=5e-06 l=5e-06 m=1.0
*************************************************************

********************* dut testbench 13_0 *********************
v_ds_13_0 d_13_0 0 1.6
e_gs_13_0 g_13_0 0 v_sweep 0 1
v_s_13_0 s_13_0 0 0
v_bs_13_0 b_13_0 0 -1.0
x_13_0 d_13_0 g_13_0 s_13_0 b_13_0 dut w=5e-06 l=5e-06 m=1.0
*************************************************************

********************* dut testbench 13_1 *********************
v_ds_13_1 d_13_1 0 1.6
e_gs_13_1 g_13_1 0 v_sweep 0 1
v_s_13_1 s_13_1 0 0
v_bs_13_1 b_13_1 0 -0.75
x_13_1 d_13_1 g_13_1 s_13_1 b_13_1 dut w=5e-06 l=5e-06 m=1.0
*************************************************************

********************* dut testbench 13_2 *********************
v_ds_13_2 d_13_2 0 1.6
e_gs_13_2 g_13_2 0 v_sweep 0 1
v_s_13_2 s_13_2 0 0
v_bs_13_2 b_13_2 0 -0.5
x_13_2 d_13_2 g_13_2 s_13_2 b_13_2 dut w=5e-06 l=5e-06 m=1.0
*************************************************************

********************* dut testbench 13_3 *********************
v_ds_13_3 d_13_3 0 1.6
e_gs_13_3 g_13_3 0 v_sweep 0 1
v_s_13_3 s_13_3 0 0
v_bs_13_3 b_13_3 0 -0.25
x_13_3 d_13_3 g_13_3 s_13_3 b_13_3 dut w=5e-06 l=5e-06 m=1.0
*************************************************************

********************* dut testbench 13_4 *********************
v_ds_13_4 d_13_4 0 1.6
e_gs_13_4 g_13_4 0 v_sweep 0 1
v_s_13_4 s_13_4 0 0
v_bs_13_4 b_13_4 0 0.0
x_13_4 d_13_4 g_13_4 s_13_4 b_13_4 dut w=5e-06 l=5e-06 m=1.0
*************************************************************

********************* dut testbench 14_0 *********************
v_ds_14_0 d_14_0 0 0.05
e_gs_14_0 g_14_0 0 v_sweep 0 1
v_s_14_0 s_14_0 0 0
v_bs_14_0 b_14_0 0 -1.0
x_14_0 d_14_0 g_14_0 s_14_0 b_14_0 dut w=1e-06 l=1e-06 m=1.0
*************************************************************

********************* dut testbench 14_1 *********************
v_ds_14_1 d_14_1 0 0.05
e_gs_14_1 g_14_1 0 v_sweep 0 1
v_s_14_1 s_14_1 0 0
v_bs_14_1 b_14_1 0 -0.75
x_14_1 d_14_1 g_14_1 s_14_1 b_14_1 dut w=1e-06 l=1e-06 m=1.0
*************************************************************

********************* dut testbench 14_2 *********************
v_ds_14_2 d_14_2 0 0.05
e_gs_14_2 g_14_2 0 v_sweep 0 1
v_s_14_2 s_14_2 0 0
v_bs_14_2 b_14_2 0 -0.5
x_14_2 d_14_2 g_14_2 s_14_2 b_14_2 dut w=1e-06 l=1e-06 m=1.0
*************************************************************

********************* dut testbench 14_3 *********************
v_ds_14_3 d_14_3 0 0.05
e_gs_14_3 g_14_3 0 v_sweep 0 1
v_s_14_3 s_14_3 0 0
v_bs_14_3 b_14_3 0 -0.25
x_14_3 d_14_3 g_14_3 s_14_3 b_14_3 dut w=1e-06 l=1e-06 m=1.0
*************************************************************

********************* dut testbench 14_4 *********************
v_ds_14_4 d_14_4 0 0.05
e_gs_14_4 g_14_4 0 v_sweep 0 1
v_s_14_4 s_14_4 0 0
v_bs_14_4 b_14_4 0 0.0
x_14_4 d_14_4 g_14_4 s_14_4 b_14_4 dut w=1e-06 l=1e-06 m=1.0
*************************************************************

********************* dut testbench 15_0 *********************
v_ds_15_0 d_15_0 0 1.6
e_gs_15_0 g_15_0 0 v_sweep 0 1
v_s_15_0 s_15_0 0 0
v_bs_15_0 b_15_0 0 -1.0
x_15_0 d_15_0 g_15_0 s_15_0 b_15_0 dut w=1e-06 l=1e-06 m=1.0
*************************************************************

********************* dut testbench 15_1 *********************
v_ds_15_1 d_15_1 0 1.6
e_gs_15_1 g_15_1 0 v_sweep 0 1
v_s_15_1 s_15_1 0 0
v_bs_15_1 b_15_1 0 -0.75
x_15_1 d_15_1 g_15_1 s_15_1 b_15_1 dut w=1e-06 l=1e-06 m=1.0
*************************************************************

********************* dut testbench 15_2 *********************
v_ds_15_2 d_15_2 0 1.6
e_gs_15_2 g_15_2 0 v_sweep 0 1
v_s_15_2 s_15_2 0 0
v_bs_15_2 b_15_2 0 -0.5
x_15_2 d_15_2 g_15_2 s_15_2 b_15_2 dut w=1e-06 l=1e-06 m=1.0
*************************************************************

********************* dut testbench 15_3 *********************
v_ds_15_3 d_15_3 0 1.6
e_gs_15_3 g_15_3 0 v_sweep 0 1
v_s_15_3 s_15_3 0 0
v_bs_15_3 b_15_3 0 -0.25
x_15_3 d_15_3 g_15_3 s_15_3 b_15_3 dut w=1e-06 l=1e-06 m=1.0
*************************************************************

********************* dut testbench 15_4 *********************
v_ds_15_4 d_15_4 0 1.6
e_gs_15_4 g_15_4 0 v_sweep 0 1
v_s_15_4 s_15_4 0 0
v_bs_15_4 b_15_4 0 0.0
x_15_4 d_15_4 g_15_4 s_15_4 b_15_4 dut w=1e-06 l=1e-06 m=1.0
*************************************************************

********************* dut testbench 16_0 *********************
v_ds_16_0 d_16_0 0 0.05
e_gs_16_0 g_16_0 0 v_sweep 0 1
v_s_16_0 s_16_0 0 0
v_bs_16_0 b_16_0 0 -1.0
x_16_0 d_16_0 g_16_0 s_16_0 b_16_0 dut w=1e-05 l=5e-06 m=1.0
*************************************************************

********************* dut testbench 16_1 *********************
v_ds_16_1 d_16_1 0 0.05
e_gs_16_1 g_16_1 0 v_sweep 0 1
v_s_16_1 s_16_1 0 0
v_bs_16_1 b_16_1 0 -0.75
x_16_1 d_16_1 g_16_1 s_16_1 b_16_1 dut w=1e-05 l=5e-06 m=1.0
*************************************************************

********************* dut testbench 16_2 *********************
v_ds_16_2 d_16_2 0 0.05
e_gs_16_2 g_16_2 0 v_sweep 0 1
v_s_16_2 s_16_2 0 0
v_bs_16_2 b_16_2 0 -0.5
x_16_2 d_16_2 g_16_2 s_16_2 b_16_2 dut w=1e-05 l=5e-06 m=1.0
*************************************************************

********************* dut testbench 16_3 *********************
v_ds_16_3 d_16_3 0 0.05
e_gs_16_3 g_16_3 0 v_sweep 0 1
v_s_16_3 s_16_3 0 0
v_bs_16_3 b_16_3 0 -0.25
x_16_3 d_16_3 g_16_3 s_16_3 b_16_3 dut w=1e-05 l=5e-06 m=1.0
*************************************************************

********************* dut testbench 16_4 *********************
v_ds_16_4 d_16_4 0 0.05
e_gs_16_4 g_16_4 0 v_sweep 0 1
v_s_16_4 s_16_4 0 0
v_bs_16_4 b_16_4 0 0.0
x_16_4 d_16_4 g_16_4 s_16_4 b_16_4 dut w=1e-05 l=5e-06 m=1.0
*************************************************************

********************* dut testbench 17_0 *********************
v_ds_17_0 d_17_0 0 1.6
e_gs_17_0 g_17_0 0 v_sweep 0 1
v_s_17_0 s_17_0 0 0
v_bs_17_0 b_17_0 0 -1.0
x_17_0 d_17_0 g_17_0 s_17_0 b_17_0 dut w=1e-05 l=5e-06 m=1.0
*************************************************************

********************* dut testbench 17_1 *********************
v_ds_17_1 d_17_1 0 1.6
e_gs_17_1 g_17_1 0 v_sweep 0 1
v_s_17_1 s_17_1 0 0
v_bs_17_1 b_17_1 0 -0.75
x_17_1 d_17_1 g_17_1 s_17_1 b_17_1 dut w=1e-05 l=5e-06 m=1.0
*************************************************************

********************* dut testbench 17_2 *********************
v_ds_17_2 d_17_2 0 1.6
e_gs_17_2 g_17_2 0 v_sweep 0 1
v_s_17_2 s_17_2 0 0
v_bs_17_2 b_17_2 0 -0.5
x_17_2 d_17_2 g_17_2 s_17_2 b_17_2 dut w=1e-05 l=5e-06 m=1.0
*************************************************************

********************* dut testbench 17_3 *********************
v_ds_17_3 d_17_3 0 1.6
e_gs_17_3 g_17_3 0 v_sweep 0 1
v_s_17_3 s_17_3 0 0
v_bs_17_3 b_17_3 0 -0.25
x_17_3 d_17_3 g_17_3 s_17_3 b_17_3 dut w=1e-05 l=5e-06 m=1.0
*************************************************************

********************* dut testbench 17_4 *********************
v_ds_17_4 d_17_4 0 1.6
e_gs_17_4 g_17_4 0 v_sweep 0 1
v_s_17_4 s_17_4 0 0
v_bs_17_4 b_17_4 0 0.0
x_17_4 d_17_4 g_17_4 s_17_4 b_17_4 dut w=1e-05 l=5e-06 m=1.0
*************************************************************

********************* dut testbench 18_0 *********************
v_ds_18_0 d_18_0 0 0.05
e_gs_18_0 g_18_0 0 v_sweep 0 1
v_s_18_0 s_18_0 0 0
v_bs_18_0 b_18_0 0 -1.0
x_18_0 d_18_0 g_18_0 s_18_0 b_18_0 dut w=5e-06 l=1e-05 m=1.0
*************************************************************

********************* dut testbench 18_1 *********************
v_ds_18_1 d_18_1 0 0.05
e_gs_18_1 g_18_1 0 v_sweep 0 1
v_s_18_1 s_18_1 0 0
v_bs_18_1 b_18_1 0 -0.75
x_18_1 d_18_1 g_18_1 s_18_1 b_18_1 dut w=5e-06 l=1e-05 m=1.0
*************************************************************

********************* dut testbench 18_2 *********************
v_ds_18_2 d_18_2 0 0.05
e_gs_18_2 g_18_2 0 v_sweep 0 1
v_s_18_2 s_18_2 0 0
v_bs_18_2 b_18_2 0 -0.5
x_18_2 d_18_2 g_18_2 s_18_2 b_18_2 dut w=5e-06 l=1e-05 m=1.0
*************************************************************

********************* dut testbench 18_3 *********************
v_ds_18_3 d_18_3 0 0.05
e_gs_18_3 g_18_3 0 v_sweep 0 1
v_s_18_3 s_18_3 0 0
v_bs_18_3 b_18_3 0 -0.25
x_18_3 d_18_3 g_18_3 s_18_3 b_18_3 dut w=5e-06 l=1e-05 m=1.0
*************************************************************

********************* dut testbench 18_4 *********************
v_ds_18_4 d_18_4 0 0.05
e_gs_18_4 g_18_4 0 v_sweep 0 1
v_s_18_4 s_18_4 0 0
v_bs_18_4 b_18_4 0 0.0
x_18_4 d_18_4 g_18_4 s_18_4 b_18_4 dut w=5e-06 l=1e-05 m=1.0
*************************************************************

********************* dut testbench 19_0 *********************
v_ds_19_0 d_19_0 0 1.6
e_gs_19_0 g_19_0 0 v_sweep 0 1
v_s_19_0 s_19_0 0 0
v_bs_19_0 b_19_0 0 -1.0
x_19_0 d_19_0 g_19_0 s_19_0 b_19_0 dut w=5e-06 l=1e-05 m=1.0
*************************************************************

********************* dut testbench 19_1 *********************
v_ds_19_1 d_19_1 0 1.6
e_gs_19_1 g_19_1 0 v_sweep 0 1
v_s_19_1 s_19_1 0 0
v_bs_19_1 b_19_1 0 -0.75
x_19_1 d_19_1 g_19_1 s_19_1 b_19_1 dut w=5e-06 l=1e-05 m=1.0
*************************************************************

********************* dut testbench 19_2 *********************
v_ds_19_2 d_19_2 0 1.6
e_gs_19_2 g_19_2 0 v_sweep 0 1
v_s_19_2 s_19_2 0 0
v_bs_19_2 b_19_2 0 -0.5
x_19_2 d_19_2 g_19_2 s_19_2 b_19_2 dut w=5e-06 l=1e-05 m=1.0
*************************************************************

********************* dut testbench 19_3 *********************
v_ds_19_3 d_19_3 0 1.6
e_gs_19_3 g_19_3 0 v_sweep 0 1
v_s_19_3 s_19_3 0 0
v_bs_19_3 b_19_3 0 -0.25
x_19_3 d_19_3 g_19_3 s_19_3 b_19_3 dut w=5e-06 l=1e-05 m=1.0
*************************************************************

********************* dut testbench 19_4 *********************
v_ds_19_4 d_19_4 0 1.6
e_gs_19_4 g_19_4 0 v_sweep 0 1
v_s_19_4 s_19_4 0 0
v_bs_19_4 b_19_4 0 0.0
x_19_4 d_19_4 g_19_4 s_19_4 b_19_4 dut w=5e-06 l=1e-05 m=1.0
*************************************************************

** End testbenches

* Declare the v_sweep, which will change during the simulation.
v_sweep v_sweep 0 0

********** Start of control section **********
.control

** Model parameters start
alterparam dut a0 = 0.7207169082419732
alterparam dut a1 = 0.037703457524796674
alterparam dut a2 = 0.9625848983645664
alterparam dut acde = 0.6614638448296188
alterparam dut ags = 0.03494866935372952
alterparam dut cf = 6.846799384322189e-11
alterparam dut cgdl = 8.756401670154964e-10
alterparam dut cgdo = 1.4072800574244665e-10
alterparam dut ckappas = 12.171002123044989
alterparam dut clc = 5.089822062185611e-08
alterparam dut cle = 0.9030880143541664
alterparam dut dlc = 1*-2.3934526352561725e-08
alterparam dut drout = 1.960786213910068
alterparam dut dsub = 0.6549965900453213
alterparam dut dvt0 = 19.857580181639044
alterparam dut dvt0w = 1*-0.5393905570327244
alterparam dut dvt1 = 0.852267063068417
alterparam dut dvt1w = 1.404744184602075
alterparam dut dvt2 = 0.06533654155115404
alterparam dut dvt2w = 1*-0.0026349657561453924
alterparam dut dwg = 9.292232457032572e-08
alterparam dut eta0 = 0.7151203132259272
alterparam dut etab = 1*-0.10973856540498506
alterparam dut k1 = 0.6704368093650003
alterparam dut k2 = 0.013297231041782459
alterparam dut k3 = 21.778370039656522
alterparam dut k3b = 1*-22.51667349984081
alterparam dut keta = 1*-0.02391678482080263
alterparam dut lint = 1*-7.711571344078094e-08
alterparam dut ll = 4.327999153410291e-14
alterparam dut moin = 16.209480100306834
alterparam dut ndep = 2.1579596122966538e+17
alterparam dut nfactor = 0.02316045676339766
alterparam dut ngate = 1.777381853902339e+20
alterparam dut noff = 1.4274313981831874
alterparam dut pclm = 0.011341835663803812
alterparam dut pdiblc1 = 0.11907439903696582
alterparam dut pdiblc2 = 0.0059069589589532245
alterparam dut pdiblcb = 1*-0.05702564902006135
alterparam dut pvag = 3.9344161251435743
alterparam dut rdsw = 2309.761765593733
alterparam dut toxp = 4.5690009188801085e-09
alterparam dut u0 = 222.09045190746957
alterparam dut ua = 1*-6.197017100028607e-09
alterparam dut ub = 1.1175212395434084e-19
alterparam dut uc = 6.4011291931475104e-09
alterparam dut voff = 1*-0.010400401940760945
alterparam dut voffcv = 1*-0.3233372393272789
alterparam dut vsat = 38949.114090803334
alterparam dut vth0 = 1.9670199539540025
alterparam dut w0 = 5.905089354350037e-07
alterparam dut wint = 1*-7.943385543934449e-08
alterparam dut ww = 1*-5.74521464250137e-14
alterparam dut wwl = 1*-5.796222090687993e-21
alterparam dut lwl = 1*-6.4630819691324e-20
alterparam dut voffl = 1*-8.291146828043814e-08
alterparam dut xpart = 0.16989620186950616
alterparam dut bin_pvsat = 0.43459718423785093
alterparam dut bin_prdsw = 0.6030147757669637
alterparam dut bin_ppclm = 0.2088839670588994
alterparam dut bin_wketa = 0.8423732752967394
alterparam dut bin_lketa = 0.47900956460767485
alterparam dut bin_pketa = 0.5083321348410523
alterparam dut bin_wk3 = 0.6138294949665571
alterparam dut bin_wk3b = 0.31314818292575325
reset
** Model parameters end

** Declare the vectors to save.
save i(v_s_18_4) i(v_s_19_1) i(v_s_10_2) v(g_16_2) v(g_19_4) i(v_s_19_3) i(v_s_14_0) v(g_13_1) i(v_s_15_2) i(v_s_11_1) v(g_14_3) v(g_11_0) i(v_s_18_1) v(g_13_2) i(v_s_15_0) i(v_s_16_0) i(v_s_13_0) v(g_12_4) v(g_17_4) v(g_12_1) i(v_s_17_2) i(v_s_15_3) v(g_14_0) i(v_s_13_2) v(g_10_0) i(v_s_14_4) i(v_s_18_0) i(v_s_18_2) v(g_18_4) v(g_17_0) i(v_s_19_4) i(v_s_17_3) v(g_13_4) v(g_17_1) i(v_s_13_3) i(v_s_10_4) v(g_11_3) v(g_13_0) v(g_19_3) v(g_19_2) i(v_s_17_0) v(g_14_2) i(v_s_13_4) v(g_12_0) i(v_s_12_2) i(v_s_10_0) i(v_s_18_3) i(v_s_16_2) v(g_16_1) i(v_s_16_3) v(g_12_3) v(g_11_1) i(v_s_15_1) i(v_s_11_0) v(g_15_1) i(v_s_14_1) i(v_s_12_3) v(g_17_2) i(v_s_11_4) v(g_10_3) v(g_18_0) v(g_10_2) v(g_13_3) i(v_s_12_0) v(g_15_3) i(v_s_16_4) v(g_14_4) v(g_18_3) v(g_10_4) i(v_s_10_1) v(g_10_1) v(g_15_2) i(v_s_13_1) i(v_s_14_2) v(g_16_0) v(g_12_2) v(g_18_2) v(g_15_4) v(g_15_0) i(v_s_14_3) i(v_s_17_4) v(g_19_0) v(g_11_4) v(g_16_3) i(v_s_10_3) i(v_s_19_0) i(v_s_11_2) i(v_s_12_1) i(v_s_12_4) i(v_s_17_1) v(g_16_4) i(v_s_19_2) i(v_s_16_1) i(v_s_11_3) v(g_19_1) v(g_17_3) v(g_11_2) v(g_18_1) v(g_14_1) i(v_s_15_4)

** Run the dc sweep analysis.
dc v_sweep -0.5 1.6 0.1

** Save the output to file.
set wr_vecnames
set wr_singlescale
wrdata /home/gazi/Desktop/Work/custom_packages/aivalanche/aivalanche_app/src/aivalanche_app/data_store/projects/projekti_1.gazi.20bf7dd9-e8f6-4d35-86d2-f717906dc109/models/modeli_1.15059f60-5751-4550-89d6-0db412e03fff/calibration_23_07_2024-22_49_01/simulation_files/dc_sweep_9.csv i(v_s_18_4) i(v_s_19_1) i(v_s_10_2) v(g_16_2) v(g_19_4) i(v_s_19_3) i(v_s_14_0) v(g_13_1) i(v_s_15_2) i(v_s_11_1) v(g_14_3) v(g_11_0) i(v_s_18_1) v(g_13_2) i(v_s_15_0) i(v_s_16_0) i(v_s_13_0) v(g_12_4) v(g_17_4) v(g_12_1) i(v_s_17_2) i(v_s_15_3) v(g_14_0) i(v_s_13_2) v(g_10_0) i(v_s_14_4) i(v_s_18_0) i(v_s_18_2) v(g_18_4) v(g_17_0) i(v_s_19_4) i(v_s_17_3) v(g_13_4) v(g_17_1) i(v_s_13_3) i(v_s_10_4) v(g_11_3) v(g_13_0) v(g_19_3) v(g_19_2) i(v_s_17_0) v(g_14_2) i(v_s_13_4) v(g_12_0) i(v_s_12_2) i(v_s_10_0) i(v_s_18_3) i(v_s_16_2) v(g_16_1) i(v_s_16_3) v(g_12_3) v(g_11_1) i(v_s_15_1) i(v_s_11_0) v(g_15_1) i(v_s_14_1) i(v_s_12_3) v(g_17_2) i(v_s_11_4) v(g_10_3) v(g_18_0) v(g_10_2) v(g_13_3) i(v_s_12_0) v(g_15_3) i(v_s_16_4) v(g_14_4) v(g_18_3) v(g_10_4) i(v_s_10_1) v(g_10_1) v(g_15_2) i(v_s_13_1) i(v_s_14_2) v(g_16_0) v(g_12_2) v(g_18_2) v(g_15_4) v(g_15_0) i(v_s_14_3) i(v_s_17_4) v(g_19_0) v(g_11_4) v(g_16_3) i(v_s_10_3) i(v_s_19_0) i(v_s_11_2) i(v_s_12_1) i(v_s_12_4) i(v_s_17_1) v(g_16_4) i(v_s_19_2) i(v_s_16_1) i(v_s_11_3) v(g_19_1) v(g_17_3) v(g_11_2) v(g_18_1) v(g_14_1) i(v_s_15_4)

.endc
********** End of control section **********

.end
