**********************************************************
* THIS FILE IS GENERATED BY AIVALANCHE
* FILE ID: 2
* SIMULATION TYPE: ac_point_dc_sweep
**********************************************************

* Define the temperature
.TEMP 25.0

* Include the dut file
.INCLUDE /home/gazi/Desktop/Work/custom_packages/aivalanche/aivalanche_app/src/aivalanche_app/data_store/projects/projekti_1.gazi.20bf7dd9-e8f6-4d35-86d2-f717906dc109/common/model_files/dut_1.cir

** Start testbenches

********************* dut testbench 22_0 *********************
v_gs_ac_22_0 g_22_0 g_ac_22_0 DC 0 AC 1
e_gs_22_0 g_ac_22_0 0 v_sweep 0 1
v_ds_22_0 d_22_0 0 0.0
v_s_22_0 s_22_0 0 0
v_bs_22_0 b_22_0 0 0.0
x_22_0 d_22_0 g_22_0 s_22_0 b_22_0 dut w=5e-06 l=6e-06 m=1.0
*************************************************************

********************* dut testbench 22_1 *********************
v_gs_ac_22_1 g_22_1 g_ac_22_1 DC 0 AC 1
e_gs_22_1 g_ac_22_1 0 v_sweep 0 1
v_ds_22_1 d_22_1 0 0.0
v_s_22_1 s_22_1 0 0
v_bs_22_1 b_22_1 0 1.0
x_22_1 d_22_1 g_22_1 s_22_1 b_22_1 dut w=5e-06 l=6e-06 m=1.0
*************************************************************

********************* dut testbench 22_2 *********************
v_gs_ac_22_2 g_22_2 g_ac_22_2 DC 0 AC 1
e_gs_22_2 g_ac_22_2 0 v_sweep 0 1
v_ds_22_2 d_22_2 0 0.0
v_s_22_2 s_22_2 0 0
v_bs_22_2 b_22_2 0 -1.0
x_22_2 d_22_2 g_22_2 s_22_2 b_22_2 dut w=5e-06 l=6e-06 m=1.0
*************************************************************

** End testbenches

* Declare the v_sweep, which will change during the simulation.
v_sweep v_sweep 0 0

********** Start of control section **********
.control

** Model parameters start
alterparam dut a0 = 1.9382410779227477
alterparam dut a1 = 0.05253281408488915
alterparam dut a2 = 0.564785374038522
alterparam dut acde = 0.5562074982275315
alterparam dut ags = 0.192913727808034
alterparam dut cf = 1.8104224595931708e-10
alterparam dut cgdl = 4.135124177400949e-09
alterparam dut cgdo = 2.6070170115464266e-10
alterparam dut ckappas = 6.197220514154675
alterparam dut clc = 1.8048599639321205e-07
alterparam dut cle = 0.9458667656307382
alterparam dut dlc = 1*-8.892872958764995e-09
alterparam dut drout = 0.20179947081576227
alterparam dut dsub = 0.8703713551200459
alterparam dut dvt0 = 3.860998532296343
alterparam dut dvt0w = 2.606963158251555
alterparam dut dvt1 = 1.0544022224593264
alterparam dut dvt1w = 1978256.3595557723
alterparam dut dvt2 = 0.006349563149579518
alterparam dut dvt2w = 1*-0.00662518534910491
alterparam dut dwg = 2.3764080661378105e-08
alterparam dut eta0 = 0.5326809054881391
alterparam dut etab = 1*-0.2359550459358447
alterparam dut k1 = 0.7696775134728722
alterparam dut k2 = 0.03312439440622457
alterparam dut k3 = 3.431185556871455
alterparam dut k3b = 12.481868702016442
alterparam dut keta = 1*-0.0834634191107316
alterparam dut lint = 1*-2.242180983952737e-08
alterparam dut ll = 6.925464808281264e-14
alterparam dut moin = 18.969167548976085
alterparam dut ndep = 4.3242519171673536e+17
alterparam dut nfactor = 2.126723037540755
alterparam dut ngate = 6.7381603841042964e+19
alterparam dut noff = 1.9284384304706907
alterparam dut pclm = 0.0009742007944117486
alterparam dut pdiblc1 = 0.001616915361411217
alterparam dut pdiblc2 = 3.056664485961424e-06
alterparam dut pdiblcb = 1*-0.7750361495068481
alterparam dut pvag = 3.6833694255703673
alterparam dut rdsw = 2072.682403411233
alterparam dut toxp = 7.925659736988466e-09
alterparam dut u0 = 230.7406117016927
alterparam dut ua = 1*-9.950507417836634e-10
alterparam dut ub = 2.3597054664915445e-20
alterparam dut uc = 1*-1.4142961381997602e-09
alterparam dut voff = 1*-0.08890353848937285
alterparam dut voffcv = 1*-0.2073289481870093
alterparam dut vsat = 35111.10953225491
alterparam dut vth0 = 0.20376325035583687
alterparam dut w0 = 1.0882257380279937e-08
alterparam dut wint = 1*-6.73396769128085e-08
alterparam dut ww = 1*-6.169491281269625e-14
alterparam dut wwl = 6.793868768225128e-20
alterparam dut lwl = 9.86611207697707e-20
alterparam dut voffl = 1*-6.104433414914349e-08
alterparam dut xpart = 0.24896775535202315
alterparam dut bin_pvsat = 0.8746416096608445
alterparam dut bin_prdsw = 0.4848266159745277
alterparam dut bin_ppclm = 0.09408512172365191
alterparam dut bin_wketa = 0.27091738485537104
alterparam dut bin_lketa = 0.06726901905710803
alterparam dut bin_pketa = 0.44629939510283334
alterparam dut bin_wk3 = 0.9248126481986142
alterparam dut bin_wk3b = 0.19710256062987241
reset
** Model parameters end

** Declare the vectors to save.
save i(v_bs_22_1) i(v_bs_22_0) i(v_bs_22_2)

** Write the header of the results file.
echo "vgs,cgb_22_2,cgb_22_1,cgb_22_0" > /home/gazi/Desktop/Work/custom_packages/aivalanche/aivalanche_app/src/aivalanche_app/data_store/projects/projekti_1.gazi.20bf7dd9-e8f6-4d35-86d2-f717906dc109/models/modeli_1.15059f60-5751-4550-89d6-0db412e03fff/calibration_23_07_2024-21_45_35/simulation_files/ac_point_dc_sweep_2.csv

** Start the simulation loop.
compose values_list start=-2.0 stop=2.0 step=0.05
foreach val $&values_list
    alter v_sweep $val
    ac lin 1 10000.0 10000.0

    let cgb_22_0 = abs(imag(i(v_bs_22_0)))/2*pi*10000.0
    let cgb_22_1 = abs(imag(i(v_bs_22_1)))/2*pi*10000.0
    let cgb_22_2 = abs(imag(i(v_bs_22_2)))/2*pi*10000.0

    echo "$val,$&cgb_22_2,$&cgb_22_1,$&cgb_22_0" >> /home/gazi/Desktop/Work/custom_packages/aivalanche/aivalanche_app/src/aivalanche_app/data_store/projects/projekti_1.gazi.20bf7dd9-e8f6-4d35-86d2-f717906dc109/models/modeli_1.15059f60-5751-4550-89d6-0db412e03fff/calibration_23_07_2024-21_45_35/simulation_files/ac_point_dc_sweep_2.csv
end

.endc
********** End of control section **********

.end
