**********************************************************
* THIS FILE IS GENERATED BY AIVALANCHE
* FILE ID: 4
* SIMULATION TYPE: ac_point_dc_sweep
**********************************************************

* Define the temperature
.TEMP 25.0

* Include the dut file
.INCLUDE /home/gazi/Desktop/Work/custom_packages/aivalanche/aivalanche_app/src/aivalanche_app/data_store/projects/project_1.gazi.5ce9039e-e488-419b-92e8-c95a713c4994/common/model_files/dut.cir

** Start testbenches

********************* dut testbench 23_0 *********************
v_gs_ac_23_0 g_23_0 g_ac_23_0 DC 0 AC 1
e_gs_23_0 g_ac_23_0 0 v_sweep 0 1
v_ds_23_0 d_23_0 0 0.0
v_s_23_0 s_23_0 0 0
v_bs_23_0 b_23_0 0 0.0
x_23_0 d_23_0 g_23_0 s_23_0 b_23_0 dut w=5e-06 l=6e-06 m=1.0
*************************************************************

** End testbenches

* Declare the v_sweep, which will change during the simulation.
v_sweep v_sweep 0 0

********** Start of control section **********
.control

** Model parameters start
alterparam dut a0 = 2.626125009348153
alterparam dut a1 = 0.05088217142409034
alterparam dut a2 = 0.5946952970911885
alterparam dut acde = 0.6040943204774073
alterparam dut ags = 1.1072049080931825
alterparam dut bin_lketa = 0.5801339681251597
alterparam dut bin_pketa = 0.21893077442656117
alterparam dut bin_ppclm = 0.2302504168614232
alterparam dut bin_prdsw = 0.1657314960359324
alterparam dut bin_pvsat = 0.8437752622664191
alterparam dut bin_wk3 = 0.8439336703177824
alterparam dut bin_wk3b = 0.5287579554092193
alterparam dut bin_wketa = 0.2605051011463085
alterparam dut cf = 1.7898894163002573e-10
alterparam dut cgdl = 6.148372987487574e-10
alterparam dut cgdo = 3.229479323306168e-10
alterparam dut ckappas = 13.625848985112958
alterparam dut clc = 3.4059897922918125e-08
alterparam dut cle = 0.6320842741814965
alterparam dut dlc = 3.1206659810964594e-08
alterparam dut drout = 1.606298599243046
alterparam dut dsub = 0.33899632521464007
alterparam dut dvt0 = 9.348216928087822
alterparam dut dvt0w = 9.147961189439465
alterparam dut dvt1 = 1.4517654371803352
alterparam dut dvt1w = 31.03073845826344
alterparam dut dvt2 = 1*-0.07421757726239225
alterparam dut dvt2w = 1*-0.004780399724894344
alterparam dut dwg = 1.2288982194797635e-08
alterparam dut eta0 = 0.19564157983904398
alterparam dut etab = 1*-0.10488426890389202
alterparam dut k1 = 0.06616739376322876
alterparam dut k2 = 0.011125391543644989
alterparam dut k3 = 67.85946618308395
alterparam dut k3b = 1*-19.60802463020844
alterparam dut keta = 1*-0.04719534597375924
alterparam dut lint = 1*-5.155602414649769e-08
alterparam dut ll = 9.61453132805084e-14
alterparam dut lwl = 1*-2.598267962804297e-21
alterparam dut moin = 23.85750162490291
alterparam dut ndep = 2.513137011637006e+16
alterparam dut nfactor = 0.9301732048423627
alterparam dut ngate = 1.1651553986299767e+19
alterparam dut noff = 1.3688975561110386
alterparam dut pclm = 8.773071843847125e-08
alterparam dut pdiblc1 = 6.987591244064103e-07
alterparam dut pdiblc2 = 0.0008759361914234717
alterparam dut pdiblcb = 1*-0.8100930349728017
alterparam dut pvag = 1.2462766280624296
alterparam dut rdsw = 729.7610475717817
alterparam dut toxp = 2.5283648400390646e-09
alterparam dut u0 = 255.1859415424868
alterparam dut ua = 1.563369125859135e-10
alterparam dut ub = 3.7970351166965e-21
alterparam dut uc = 3.0318084569789787e-09
alterparam dut voff = 1*-0.010636654646327653
alterparam dut voffcv = 1*-0.14931210619627294
alterparam dut voffl = 1.7224654220201368e-09
alterparam dut vsat = 120288.02068995887
alterparam dut vth0 = 1.6502996151425715
alterparam dut w0 = 1.0482874077450323e-08
alterparam dut wint = 1*-8.831661153537918e-08
alterparam dut ww = 1*-9.396706795154786e-14
alterparam dut wwl = 6.826105009382718e-20
alterparam dut xpart = 0.8251506129387414
reset
** Model parameters end

** Declare the vectors to save.
save i(v_bs_23_0) i(v_ds_23_0) i(v_s_23_0)

** Write the header of the results file.
echo "vgs,cgg_23_0" > /home/gazi/Desktop/Work/custom_packages/aivalanche/aivalanche_app/src/aivalanche_app/data_store/projects/project_1.gazi.5ce9039e-e488-419b-92e8-c95a713c4994/models/model_1.0e00713a-4f68-42d4-9653-2a40c98c558f/calibration_07_08_2024-19_16_19/simulation_files/ac_point_dc_sweep_4.csv

** Start the simulation loop.
compose values_list start=-2.0 stop=2.0 step=0.05
foreach val $&values_list
    alter v_sweep $val
    ac lin 1 10000.0 10000.0

    let cgg_23_0 = (abs(imag(i(v_s_23_0))) + abs(imag(i(v_ds_23_0))) + abs(imag(i(v_bs_23_0))))/2*pi*10000.0

    echo "$val,$&cgg_23_0" >> /home/gazi/Desktop/Work/custom_packages/aivalanche/aivalanche_app/src/aivalanche_app/data_store/projects/project_1.gazi.5ce9039e-e488-419b-92e8-c95a713c4994/models/model_1.0e00713a-4f68-42d4-9653-2a40c98c558f/calibration_07_08_2024-19_16_19/simulation_files/ac_point_dc_sweep_4.csv
end

.endc
********** End of control section **********

.end
