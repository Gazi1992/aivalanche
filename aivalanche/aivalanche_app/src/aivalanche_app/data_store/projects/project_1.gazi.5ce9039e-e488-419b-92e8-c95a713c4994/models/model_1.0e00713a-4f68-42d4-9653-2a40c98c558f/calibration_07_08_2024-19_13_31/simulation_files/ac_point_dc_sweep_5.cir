**********************************************************
* THIS FILE IS GENERATED BY AIVALANCHE
* FILE ID: 5
* SIMULATION TYPE: ac_point_dc_sweep
**********************************************************

* Define the temperature
.TEMP 25.0

* Include the dut file
.INCLUDE /home/gazi/Desktop/Work/custom_packages/aivalanche/aivalanche_app/src/aivalanche_app/data_store/projects/project_1.gazi.5ce9039e-e488-419b-92e8-c95a713c4994/common/model_files/dut.cir

** Start testbenches

********************* dut testbench 21_0 *********************
v_gs_ac_21_0 g_21_0 g_ac_21_0 DC 0 AC 1
e_gs_21_0 g_ac_21_0 0 v_sweep 0 1
v_ds_21_0 d_21_0 0 0.0
v_s_21_0 s_21_0 0 0
v_bs_21_0 b_21_0 0 0.0
x_21_0 d_21_0 g_21_0 s_21_0 b_21_0 dut w=5e-06 l=6e-06 m=1.0
*************************************************************

********************* dut testbench 21_2 *********************
v_gs_ac_21_2 g_21_2 g_ac_21_2 DC 0 AC 1
e_gs_21_2 g_ac_21_2 0 v_sweep 0 1
v_ds_21_2 d_21_2 0 0.0
v_s_21_2 s_21_2 0 0
v_bs_21_2 b_21_2 0 -1.0
x_21_2 d_21_2 g_21_2 s_21_2 b_21_2 dut w=5e-06 l=6e-06 m=1.0
*************************************************************

** End testbenches

* Declare the v_sweep, which will change during the simulation.
v_sweep v_sweep 0 0

********** Start of control section **********
.control

** Model parameters start
alterparam dut a0 = 1.2937094785101237
alterparam dut a1 = 0.05826060817531292
alterparam dut a2 = 0.026730354585731336
alterparam dut acde = 1.5805741406051987
alterparam dut ags = 0.3932198666869464
alterparam dut bin_lketa = 0.31973124232025274
alterparam dut bin_pketa = 0.18478002691335282
alterparam dut bin_ppclm = 0.23780176048813403
alterparam dut bin_prdsw = 0.5951550158621742
alterparam dut bin_pvsat = 0.8574692428908665
alterparam dut bin_wk3 = 0.2421411353831801
alterparam dut bin_wk3b = 0.028308875677266476
alterparam dut bin_wketa = 0.7562953888804625
alterparam dut cf = 1.769400085651038e-10
alterparam dut cgdl = 4.795347286470063e-09
alterparam dut cgdo = 1.9975162424348913e-10
alterparam dut ckappas = 0.5653970630266125
alterparam dut clc = 1.3457691036133088e-07
alterparam dut cle = 0.7322389901062831
alterparam dut dlc = 6.310485566799817e-08
alterparam dut drout = 1.5693306119636736
alterparam dut dsub = 0.42233003224447696
alterparam dut dvt0 = 17.957674747171176
alterparam dut dvt0w = 4.531054095369372
alterparam dut dvt1 = 0.46740526280821393
alterparam dut dvt1w = 0.1475036306665623
alterparam dut dvt2 = 0.0728233833016646
alterparam dut dvt2w = 1*-0.01218516854474768
alterparam dut dwg = 3.748967820434991e-08
alterparam dut eta0 = 0.9345762627924593
alterparam dut etab = 1*-0.00626809330721545
alterparam dut k1 = 0.10663078325586373
alterparam dut k2 = 1*-0.0458587345589546
alterparam dut k3 = 1*-91.39661782652419
alterparam dut k3b = 1*-17.41366939134275
alterparam dut keta = 1*-0.006713715496573111
alterparam dut lint = 1*-5.970434844685687e-08
alterparam dut ll = 8.279525677688919e-15
alterparam dut lwl = 6.117649890059654e-20
alterparam dut moin = 24.231051232275735
alterparam dut ndep = 4.86887358207262e+17
alterparam dut nfactor = 1.5695452013811282
alterparam dut ngate = 3.5789746068387185e+19
alterparam dut noff = 3.4841259938475586
alterparam dut pclm = 0.003083215531148329
alterparam dut pdiblc1 = 2.669138492348154e-05
alterparam dut pdiblc2 = 1.2072327996842383e-05
alterparam dut pdiblcb = 1*-0.036336636210468676
alterparam dut pvag = 3.0762228417329345
alterparam dut rdsw = 2034.2561675611112
alterparam dut toxp = 5.642659142686204e-09
alterparam dut u0 = 679.4255759668404
alterparam dut ua = 6.729197645207437e-10
alterparam dut ub = 5.327313302391265e-19
alterparam dut uc = 1*-2.5941250697834373e-09
alterparam dut voff = 1*-0.0001402691997631489
alterparam dut voffcv = 0.2021492221573329
alterparam dut voffl = 1*-7.51625947112671e-08
alterparam dut vsat = 255706.13442882895
alterparam dut vth0 = 1*-1.3428046633626125
alterparam dut w0 = 2.5449708426009607e-06
alterparam dut wint = 8.188754579644564e-08
alterparam dut ww = 1*-8.134243872936293e-14
alterparam dut wwl = 1*-7.737740557973894e-20
alterparam dut xpart = 0.40841121564500116
reset
** Model parameters end

** Declare the vectors to save.
save i(v_s_21_2) i(v_s_21_0)

** Write the header of the results file.
echo "vgs,cgs_21_2,cgs_21_0" > /home/gazi/Desktop/Work/custom_packages/aivalanche/aivalanche_app/src/aivalanche_app/data_store/projects/project_1.gazi.5ce9039e-e488-419b-92e8-c95a713c4994/models/model_1.0e00713a-4f68-42d4-9653-2a40c98c558f/calibration_07_08_2024-19_13_31/simulation_files/ac_point_dc_sweep_5.csv

** Start the simulation loop.
compose values_list start=-2.0 stop=2.0 step=0.05
foreach val $&values_list
    alter v_sweep $val
    ac lin 1 10000.0 10000.0

    let cgs_21_0 = abs(imag(i(v_s_21_0)))/2*pi*10000.0
    let cgs_21_2 = abs(imag(i(v_s_21_2)))/2*pi*10000.0

    echo "$val,$&cgs_21_2,$&cgs_21_0" >> /home/gazi/Desktop/Work/custom_packages/aivalanche/aivalanche_app/src/aivalanche_app/data_store/projects/project_1.gazi.5ce9039e-e488-419b-92e8-c95a713c4994/models/model_1.0e00713a-4f68-42d4-9653-2a40c98c558f/calibration_07_08_2024-19_13_31/simulation_files/ac_point_dc_sweep_5.csv
end

.endc
********** End of control section **********

.end
