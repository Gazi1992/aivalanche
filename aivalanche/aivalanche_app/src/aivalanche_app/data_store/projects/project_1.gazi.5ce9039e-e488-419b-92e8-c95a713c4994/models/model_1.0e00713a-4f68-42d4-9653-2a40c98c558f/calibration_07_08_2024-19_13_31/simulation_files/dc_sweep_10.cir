**********************************************************
* THIS FILE IS GENERATED BY AIVALANCHE
* FILE ID: 10
* SIMULATION TYPE: dc_sweep
**********************************************************

* Define the temperature
.TEMP 25.0

* Include the dut file
.INCLUDE /home/gazi/Desktop/Work/custom_packages/aivalanche/aivalanche_app/src/aivalanche_app/data_store/projects/project_1.gazi.5ce9039e-e488-419b-92e8-c95a713c4994/common/model_files/dut.cir

** Start testbenches

********************* dut testbench 0_0 *********************
e_ds_0_0 d_0_0 0 v_sweep 0 1
v_gs_0_0 g_0_0 0 0.2
v_s_0_0 s_0_0 0 0
v_bs_0_0 b_0_0 0 -1.0
x_0_0 d_0_0 g_0_0 s_0_0 b_0_0 dut w=1e-05 l=1e-05 m=1.0
*************************************************************

********************* dut testbench 0_1 *********************
e_ds_0_1 d_0_1 0 v_sweep 0 1
v_gs_0_1 g_0_1 0 0.4
v_s_0_1 s_0_1 0 0
v_bs_0_1 b_0_1 0 -1.0
x_0_1 d_0_1 g_0_1 s_0_1 b_0_1 dut w=1e-05 l=1e-05 m=1.0
*************************************************************

********************* dut testbench 0_2 *********************
e_ds_0_2 d_0_2 0 v_sweep 0 1
v_gs_0_2 g_0_2 0 0.6
v_s_0_2 s_0_2 0 0
v_bs_0_2 b_0_2 0 -1.0
x_0_2 d_0_2 g_0_2 s_0_2 b_0_2 dut w=1e-05 l=1e-05 m=1.0
*************************************************************

********************* dut testbench 0_3 *********************
e_ds_0_3 d_0_3 0 v_sweep 0 1
v_gs_0_3 g_0_3 0 0.8
v_s_0_3 s_0_3 0 0
v_bs_0_3 b_0_3 0 -1.0
x_0_3 d_0_3 g_0_3 s_0_3 b_0_3 dut w=1e-05 l=1e-05 m=1.0
*************************************************************

********************* dut testbench 0_4 *********************
e_ds_0_4 d_0_4 0 v_sweep 0 1
v_gs_0_4 g_0_4 0 1.0
v_s_0_4 s_0_4 0 0
v_bs_0_4 b_0_4 0 -1.0
x_0_4 d_0_4 g_0_4 s_0_4 b_0_4 dut w=1e-05 l=1e-05 m=1.0
*************************************************************

********************* dut testbench 0_5 *********************
e_ds_0_5 d_0_5 0 v_sweep 0 1
v_gs_0_5 g_0_5 0 1.2
v_s_0_5 s_0_5 0 0
v_bs_0_5 b_0_5 0 -1.0
x_0_5 d_0_5 g_0_5 s_0_5 b_0_5 dut w=1e-05 l=1e-05 m=1.0
*************************************************************

********************* dut testbench 0_6 *********************
e_ds_0_6 d_0_6 0 v_sweep 0 1
v_gs_0_6 g_0_6 0 1.4
v_s_0_6 s_0_6 0 0
v_bs_0_6 b_0_6 0 -1.0
x_0_6 d_0_6 g_0_6 s_0_6 b_0_6 dut w=1e-05 l=1e-05 m=1.0
*************************************************************

********************* dut testbench 0_7 *********************
e_ds_0_7 d_0_7 0 v_sweep 0 1
v_gs_0_7 g_0_7 0 1.6
v_s_0_7 s_0_7 0 0
v_bs_0_7 b_0_7 0 -1.0
x_0_7 d_0_7 g_0_7 s_0_7 b_0_7 dut w=1e-05 l=1e-05 m=1.0
*************************************************************

********************* dut testbench 1_0 *********************
e_ds_1_0 d_1_0 0 v_sweep 0 1
v_gs_1_0 g_1_0 0 0.2
v_s_1_0 s_1_0 0 0
v_bs_1_0 b_1_0 0 0.0
x_1_0 d_1_0 g_1_0 s_1_0 b_1_0 dut w=1e-05 l=1e-05 m=1.0
*************************************************************

********************* dut testbench 1_1 *********************
e_ds_1_1 d_1_1 0 v_sweep 0 1
v_gs_1_1 g_1_1 0 0.4
v_s_1_1 s_1_1 0 0
v_bs_1_1 b_1_1 0 0.0
x_1_1 d_1_1 g_1_1 s_1_1 b_1_1 dut w=1e-05 l=1e-05 m=1.0
*************************************************************

********************* dut testbench 1_2 *********************
e_ds_1_2 d_1_2 0 v_sweep 0 1
v_gs_1_2 g_1_2 0 0.6
v_s_1_2 s_1_2 0 0
v_bs_1_2 b_1_2 0 0.0
x_1_2 d_1_2 g_1_2 s_1_2 b_1_2 dut w=1e-05 l=1e-05 m=1.0
*************************************************************

********************* dut testbench 1_3 *********************
e_ds_1_3 d_1_3 0 v_sweep 0 1
v_gs_1_3 g_1_3 0 0.8
v_s_1_3 s_1_3 0 0
v_bs_1_3 b_1_3 0 0.0
x_1_3 d_1_3 g_1_3 s_1_3 b_1_3 dut w=1e-05 l=1e-05 m=1.0
*************************************************************

********************* dut testbench 1_5 *********************
e_ds_1_5 d_1_5 0 v_sweep 0 1
v_gs_1_5 g_1_5 0 1.2
v_s_1_5 s_1_5 0 0
v_bs_1_5 b_1_5 0 0.0
x_1_5 d_1_5 g_1_5 s_1_5 b_1_5 dut w=1e-05 l=1e-05 m=1.0
*************************************************************

********************* dut testbench 1_6 *********************
e_ds_1_6 d_1_6 0 v_sweep 0 1
v_gs_1_6 g_1_6 0 1.4
v_s_1_6 s_1_6 0 0
v_bs_1_6 b_1_6 0 0.0
x_1_6 d_1_6 g_1_6 s_1_6 b_1_6 dut w=1e-05 l=1e-05 m=1.0
*************************************************************

********************* dut testbench 1_7 *********************
e_ds_1_7 d_1_7 0 v_sweep 0 1
v_gs_1_7 g_1_7 0 1.6
v_s_1_7 s_1_7 0 0
v_bs_1_7 b_1_7 0 0.0
x_1_7 d_1_7 g_1_7 s_1_7 b_1_7 dut w=1e-05 l=1e-05 m=1.0
*************************************************************

********************* dut testbench 2_0 *********************
e_ds_2_0 d_2_0 0 v_sweep 0 1
v_gs_2_0 g_2_0 0 0.2
v_s_2_0 s_2_0 0 0
v_bs_2_0 b_2_0 0 -1.0
x_2_0 d_2_0 g_2_0 s_2_0 b_2_0 dut w=5e-06 l=5e-06 m=1.0
*************************************************************

********************* dut testbench 2_1 *********************
e_ds_2_1 d_2_1 0 v_sweep 0 1
v_gs_2_1 g_2_1 0 0.4
v_s_2_1 s_2_1 0 0
v_bs_2_1 b_2_1 0 -1.0
x_2_1 d_2_1 g_2_1 s_2_1 b_2_1 dut w=5e-06 l=5e-06 m=1.0
*************************************************************

********************* dut testbench 2_2 *********************
e_ds_2_2 d_2_2 0 v_sweep 0 1
v_gs_2_2 g_2_2 0 0.6
v_s_2_2 s_2_2 0 0
v_bs_2_2 b_2_2 0 -1.0
x_2_2 d_2_2 g_2_2 s_2_2 b_2_2 dut w=5e-06 l=5e-06 m=1.0
*************************************************************

********************* dut testbench 2_3 *********************
e_ds_2_3 d_2_3 0 v_sweep 0 1
v_gs_2_3 g_2_3 0 0.8
v_s_2_3 s_2_3 0 0
v_bs_2_3 b_2_3 0 -1.0
x_2_3 d_2_3 g_2_3 s_2_3 b_2_3 dut w=5e-06 l=5e-06 m=1.0
*************************************************************

********************* dut testbench 2_4 *********************
e_ds_2_4 d_2_4 0 v_sweep 0 1
v_gs_2_4 g_2_4 0 1.0
v_s_2_4 s_2_4 0 0
v_bs_2_4 b_2_4 0 -1.0
x_2_4 d_2_4 g_2_4 s_2_4 b_2_4 dut w=5e-06 l=5e-06 m=1.0
*************************************************************

********************* dut testbench 2_5 *********************
e_ds_2_5 d_2_5 0 v_sweep 0 1
v_gs_2_5 g_2_5 0 1.2
v_s_2_5 s_2_5 0 0
v_bs_2_5 b_2_5 0 -1.0
x_2_5 d_2_5 g_2_5 s_2_5 b_2_5 dut w=5e-06 l=5e-06 m=1.0
*************************************************************

********************* dut testbench 2_6 *********************
e_ds_2_6 d_2_6 0 v_sweep 0 1
v_gs_2_6 g_2_6 0 1.4
v_s_2_6 s_2_6 0 0
v_bs_2_6 b_2_6 0 -1.0
x_2_6 d_2_6 g_2_6 s_2_6 b_2_6 dut w=5e-06 l=5e-06 m=1.0
*************************************************************

********************* dut testbench 2_7 *********************
e_ds_2_7 d_2_7 0 v_sweep 0 1
v_gs_2_7 g_2_7 0 1.6
v_s_2_7 s_2_7 0 0
v_bs_2_7 b_2_7 0 -1.0
x_2_7 d_2_7 g_2_7 s_2_7 b_2_7 dut w=5e-06 l=5e-06 m=1.0
*************************************************************

********************* dut testbench 3_0 *********************
e_ds_3_0 d_3_0 0 v_sweep 0 1
v_gs_3_0 g_3_0 0 0.2
v_s_3_0 s_3_0 0 0
v_bs_3_0 b_3_0 0 0.0
x_3_0 d_3_0 g_3_0 s_3_0 b_3_0 dut w=5e-06 l=5e-06 m=1.0
*************************************************************

********************* dut testbench 3_1 *********************
e_ds_3_1 d_3_1 0 v_sweep 0 1
v_gs_3_1 g_3_1 0 0.4
v_s_3_1 s_3_1 0 0
v_bs_3_1 b_3_1 0 0.0
x_3_1 d_3_1 g_3_1 s_3_1 b_3_1 dut w=5e-06 l=5e-06 m=1.0
*************************************************************

********************* dut testbench 3_2 *********************
e_ds_3_2 d_3_2 0 v_sweep 0 1
v_gs_3_2 g_3_2 0 0.6
v_s_3_2 s_3_2 0 0
v_bs_3_2 b_3_2 0 0.0
x_3_2 d_3_2 g_3_2 s_3_2 b_3_2 dut w=5e-06 l=5e-06 m=1.0
*************************************************************

********************* dut testbench 3_3 *********************
e_ds_3_3 d_3_3 0 v_sweep 0 1
v_gs_3_3 g_3_3 0 0.8
v_s_3_3 s_3_3 0 0
v_bs_3_3 b_3_3 0 0.0
x_3_3 d_3_3 g_3_3 s_3_3 b_3_3 dut w=5e-06 l=5e-06 m=1.0
*************************************************************

********************* dut testbench 3_4 *********************
e_ds_3_4 d_3_4 0 v_sweep 0 1
v_gs_3_4 g_3_4 0 1.0
v_s_3_4 s_3_4 0 0
v_bs_3_4 b_3_4 0 0.0
x_3_4 d_3_4 g_3_4 s_3_4 b_3_4 dut w=5e-06 l=5e-06 m=1.0
*************************************************************

********************* dut testbench 3_5 *********************
e_ds_3_5 d_3_5 0 v_sweep 0 1
v_gs_3_5 g_3_5 0 1.2
v_s_3_5 s_3_5 0 0
v_bs_3_5 b_3_5 0 0.0
x_3_5 d_3_5 g_3_5 s_3_5 b_3_5 dut w=5e-06 l=5e-06 m=1.0
*************************************************************

********************* dut testbench 3_6 *********************
e_ds_3_6 d_3_6 0 v_sweep 0 1
v_gs_3_6 g_3_6 0 1.4
v_s_3_6 s_3_6 0 0
v_bs_3_6 b_3_6 0 0.0
x_3_6 d_3_6 g_3_6 s_3_6 b_3_6 dut w=5e-06 l=5e-06 m=1.0
*************************************************************

********************* dut testbench 3_7 *********************
e_ds_3_7 d_3_7 0 v_sweep 0 1
v_gs_3_7 g_3_7 0 1.6
v_s_3_7 s_3_7 0 0
v_bs_3_7 b_3_7 0 0.0
x_3_7 d_3_7 g_3_7 s_3_7 b_3_7 dut w=5e-06 l=5e-06 m=1.0
*************************************************************

********************* dut testbench 4_0 *********************
e_ds_4_0 d_4_0 0 v_sweep 0 1
v_gs_4_0 g_4_0 0 0.2
v_s_4_0 s_4_0 0 0
v_bs_4_0 b_4_0 0 -1.0
x_4_0 d_4_0 g_4_0 s_4_0 b_4_0 dut w=1e-06 l=1e-06 m=1.0
*************************************************************

********************* dut testbench 4_1 *********************
e_ds_4_1 d_4_1 0 v_sweep 0 1
v_gs_4_1 g_4_1 0 0.4
v_s_4_1 s_4_1 0 0
v_bs_4_1 b_4_1 0 -1.0
x_4_1 d_4_1 g_4_1 s_4_1 b_4_1 dut w=1e-06 l=1e-06 m=1.0
*************************************************************

********************* dut testbench 4_2 *********************
e_ds_4_2 d_4_2 0 v_sweep 0 1
v_gs_4_2 g_4_2 0 0.6
v_s_4_2 s_4_2 0 0
v_bs_4_2 b_4_2 0 -1.0
x_4_2 d_4_2 g_4_2 s_4_2 b_4_2 dut w=1e-06 l=1e-06 m=1.0
*************************************************************

********************* dut testbench 4_3 *********************
e_ds_4_3 d_4_3 0 v_sweep 0 1
v_gs_4_3 g_4_3 0 0.8
v_s_4_3 s_4_3 0 0
v_bs_4_3 b_4_3 0 -1.0
x_4_3 d_4_3 g_4_3 s_4_3 b_4_3 dut w=1e-06 l=1e-06 m=1.0
*************************************************************

********************* dut testbench 4_4 *********************
e_ds_4_4 d_4_4 0 v_sweep 0 1
v_gs_4_4 g_4_4 0 1.0
v_s_4_4 s_4_4 0 0
v_bs_4_4 b_4_4 0 -1.0
x_4_4 d_4_4 g_4_4 s_4_4 b_4_4 dut w=1e-06 l=1e-06 m=1.0
*************************************************************

********************* dut testbench 4_5 *********************
e_ds_4_5 d_4_5 0 v_sweep 0 1
v_gs_4_5 g_4_5 0 1.2
v_s_4_5 s_4_5 0 0
v_bs_4_5 b_4_5 0 -1.0
x_4_5 d_4_5 g_4_5 s_4_5 b_4_5 dut w=1e-06 l=1e-06 m=1.0
*************************************************************

********************* dut testbench 4_6 *********************
e_ds_4_6 d_4_6 0 v_sweep 0 1
v_gs_4_6 g_4_6 0 1.4
v_s_4_6 s_4_6 0 0
v_bs_4_6 b_4_6 0 -1.0
x_4_6 d_4_6 g_4_6 s_4_6 b_4_6 dut w=1e-06 l=1e-06 m=1.0
*************************************************************

********************* dut testbench 4_7 *********************
e_ds_4_7 d_4_7 0 v_sweep 0 1
v_gs_4_7 g_4_7 0 1.6
v_s_4_7 s_4_7 0 0
v_bs_4_7 b_4_7 0 -1.0
x_4_7 d_4_7 g_4_7 s_4_7 b_4_7 dut w=1e-06 l=1e-06 m=1.0
*************************************************************

********************* dut testbench 5_0 *********************
e_ds_5_0 d_5_0 0 v_sweep 0 1
v_gs_5_0 g_5_0 0 0.2
v_s_5_0 s_5_0 0 0
v_bs_5_0 b_5_0 0 0.0
x_5_0 d_5_0 g_5_0 s_5_0 b_5_0 dut w=1e-06 l=1e-06 m=1.0
*************************************************************

********************* dut testbench 5_1 *********************
e_ds_5_1 d_5_1 0 v_sweep 0 1
v_gs_5_1 g_5_1 0 0.4
v_s_5_1 s_5_1 0 0
v_bs_5_1 b_5_1 0 0.0
x_5_1 d_5_1 g_5_1 s_5_1 b_5_1 dut w=1e-06 l=1e-06 m=1.0
*************************************************************

********************* dut testbench 5_2 *********************
e_ds_5_2 d_5_2 0 v_sweep 0 1
v_gs_5_2 g_5_2 0 0.6
v_s_5_2 s_5_2 0 0
v_bs_5_2 b_5_2 0 0.0
x_5_2 d_5_2 g_5_2 s_5_2 b_5_2 dut w=1e-06 l=1e-06 m=1.0
*************************************************************

********************* dut testbench 5_3 *********************
e_ds_5_3 d_5_3 0 v_sweep 0 1
v_gs_5_3 g_5_3 0 0.8
v_s_5_3 s_5_3 0 0
v_bs_5_3 b_5_3 0 0.0
x_5_3 d_5_3 g_5_3 s_5_3 b_5_3 dut w=1e-06 l=1e-06 m=1.0
*************************************************************

********************* dut testbench 5_4 *********************
e_ds_5_4 d_5_4 0 v_sweep 0 1
v_gs_5_4 g_5_4 0 1.0
v_s_5_4 s_5_4 0 0
v_bs_5_4 b_5_4 0 0.0
x_5_4 d_5_4 g_5_4 s_5_4 b_5_4 dut w=1e-06 l=1e-06 m=1.0
*************************************************************

********************* dut testbench 5_5 *********************
e_ds_5_5 d_5_5 0 v_sweep 0 1
v_gs_5_5 g_5_5 0 1.2
v_s_5_5 s_5_5 0 0
v_bs_5_5 b_5_5 0 0.0
x_5_5 d_5_5 g_5_5 s_5_5 b_5_5 dut w=1e-06 l=1e-06 m=1.0
*************************************************************

********************* dut testbench 5_6 *********************
e_ds_5_6 d_5_6 0 v_sweep 0 1
v_gs_5_6 g_5_6 0 1.4
v_s_5_6 s_5_6 0 0
v_bs_5_6 b_5_6 0 0.0
x_5_6 d_5_6 g_5_6 s_5_6 b_5_6 dut w=1e-06 l=1e-06 m=1.0
*************************************************************

********************* dut testbench 5_7 *********************
e_ds_5_7 d_5_7 0 v_sweep 0 1
v_gs_5_7 g_5_7 0 1.6
v_s_5_7 s_5_7 0 0
v_bs_5_7 b_5_7 0 0.0
x_5_7 d_5_7 g_5_7 s_5_7 b_5_7 dut w=1e-06 l=1e-06 m=1.0
*************************************************************

********************* dut testbench 6_0 *********************
e_ds_6_0 d_6_0 0 v_sweep 0 1
v_gs_6_0 g_6_0 0 0.2
v_s_6_0 s_6_0 0 0
v_bs_6_0 b_6_0 0 -1.0
x_6_0 d_6_0 g_6_0 s_6_0 b_6_0 dut w=1e-05 l=5e-06 m=1.0
*************************************************************

********************* dut testbench 6_1 *********************
e_ds_6_1 d_6_1 0 v_sweep 0 1
v_gs_6_1 g_6_1 0 0.4
v_s_6_1 s_6_1 0 0
v_bs_6_1 b_6_1 0 -1.0
x_6_1 d_6_1 g_6_1 s_6_1 b_6_1 dut w=1e-05 l=5e-06 m=1.0
*************************************************************

********************* dut testbench 6_2 *********************
e_ds_6_2 d_6_2 0 v_sweep 0 1
v_gs_6_2 g_6_2 0 0.6
v_s_6_2 s_6_2 0 0
v_bs_6_2 b_6_2 0 -1.0
x_6_2 d_6_2 g_6_2 s_6_2 b_6_2 dut w=1e-05 l=5e-06 m=1.0
*************************************************************

********************* dut testbench 6_3 *********************
e_ds_6_3 d_6_3 0 v_sweep 0 1
v_gs_6_3 g_6_3 0 0.8
v_s_6_3 s_6_3 0 0
v_bs_6_3 b_6_3 0 -1.0
x_6_3 d_6_3 g_6_3 s_6_3 b_6_3 dut w=1e-05 l=5e-06 m=1.0
*************************************************************

********************* dut testbench 6_4 *********************
e_ds_6_4 d_6_4 0 v_sweep 0 1
v_gs_6_4 g_6_4 0 1.0
v_s_6_4 s_6_4 0 0
v_bs_6_4 b_6_4 0 -1.0
x_6_4 d_6_4 g_6_4 s_6_4 b_6_4 dut w=1e-05 l=5e-06 m=1.0
*************************************************************

********************* dut testbench 6_5 *********************
e_ds_6_5 d_6_5 0 v_sweep 0 1
v_gs_6_5 g_6_5 0 1.2
v_s_6_5 s_6_5 0 0
v_bs_6_5 b_6_5 0 -1.0
x_6_5 d_6_5 g_6_5 s_6_5 b_6_5 dut w=1e-05 l=5e-06 m=1.0
*************************************************************

********************* dut testbench 6_6 *********************
e_ds_6_6 d_6_6 0 v_sweep 0 1
v_gs_6_6 g_6_6 0 1.4
v_s_6_6 s_6_6 0 0
v_bs_6_6 b_6_6 0 -1.0
x_6_6 d_6_6 g_6_6 s_6_6 b_6_6 dut w=1e-05 l=5e-06 m=1.0
*************************************************************

********************* dut testbench 6_7 *********************
e_ds_6_7 d_6_7 0 v_sweep 0 1
v_gs_6_7 g_6_7 0 1.6
v_s_6_7 s_6_7 0 0
v_bs_6_7 b_6_7 0 -1.0
x_6_7 d_6_7 g_6_7 s_6_7 b_6_7 dut w=1e-05 l=5e-06 m=1.0
*************************************************************

********************* dut testbench 7_0 *********************
e_ds_7_0 d_7_0 0 v_sweep 0 1
v_gs_7_0 g_7_0 0 0.2
v_s_7_0 s_7_0 0 0
v_bs_7_0 b_7_0 0 0.0
x_7_0 d_7_0 g_7_0 s_7_0 b_7_0 dut w=1e-05 l=5e-06 m=1.0
*************************************************************

********************* dut testbench 7_1 *********************
e_ds_7_1 d_7_1 0 v_sweep 0 1
v_gs_7_1 g_7_1 0 0.4
v_s_7_1 s_7_1 0 0
v_bs_7_1 b_7_1 0 0.0
x_7_1 d_7_1 g_7_1 s_7_1 b_7_1 dut w=1e-05 l=5e-06 m=1.0
*************************************************************

********************* dut testbench 7_2 *********************
e_ds_7_2 d_7_2 0 v_sweep 0 1
v_gs_7_2 g_7_2 0 0.6
v_s_7_2 s_7_2 0 0
v_bs_7_2 b_7_2 0 0.0
x_7_2 d_7_2 g_7_2 s_7_2 b_7_2 dut w=1e-05 l=5e-06 m=1.0
*************************************************************

********************* dut testbench 7_3 *********************
e_ds_7_3 d_7_3 0 v_sweep 0 1
v_gs_7_3 g_7_3 0 0.8
v_s_7_3 s_7_3 0 0
v_bs_7_3 b_7_3 0 0.0
x_7_3 d_7_3 g_7_3 s_7_3 b_7_3 dut w=1e-05 l=5e-06 m=1.0
*************************************************************

********************* dut testbench 7_4 *********************
e_ds_7_4 d_7_4 0 v_sweep 0 1
v_gs_7_4 g_7_4 0 1.0
v_s_7_4 s_7_4 0 0
v_bs_7_4 b_7_4 0 0.0
x_7_4 d_7_4 g_7_4 s_7_4 b_7_4 dut w=1e-05 l=5e-06 m=1.0
*************************************************************

********************* dut testbench 7_5 *********************
e_ds_7_5 d_7_5 0 v_sweep 0 1
v_gs_7_5 g_7_5 0 1.2
v_s_7_5 s_7_5 0 0
v_bs_7_5 b_7_5 0 0.0
x_7_5 d_7_5 g_7_5 s_7_5 b_7_5 dut w=1e-05 l=5e-06 m=1.0
*************************************************************

********************* dut testbench 7_6 *********************
e_ds_7_6 d_7_6 0 v_sweep 0 1
v_gs_7_6 g_7_6 0 1.4
v_s_7_6 s_7_6 0 0
v_bs_7_6 b_7_6 0 0.0
x_7_6 d_7_6 g_7_6 s_7_6 b_7_6 dut w=1e-05 l=5e-06 m=1.0
*************************************************************

********************* dut testbench 7_7 *********************
e_ds_7_7 d_7_7 0 v_sweep 0 1
v_gs_7_7 g_7_7 0 1.6
v_s_7_7 s_7_7 0 0
v_bs_7_7 b_7_7 0 0.0
x_7_7 d_7_7 g_7_7 s_7_7 b_7_7 dut w=1e-05 l=5e-06 m=1.0
*************************************************************

********************* dut testbench 8_0 *********************
e_ds_8_0 d_8_0 0 v_sweep 0 1
v_gs_8_0 g_8_0 0 0.2
v_s_8_0 s_8_0 0 0
v_bs_8_0 b_8_0 0 -1.0
x_8_0 d_8_0 g_8_0 s_8_0 b_8_0 dut w=5e-06 l=1e-05 m=1.0
*************************************************************

********************* dut testbench 8_1 *********************
e_ds_8_1 d_8_1 0 v_sweep 0 1
v_gs_8_1 g_8_1 0 0.4
v_s_8_1 s_8_1 0 0
v_bs_8_1 b_8_1 0 -1.0
x_8_1 d_8_1 g_8_1 s_8_1 b_8_1 dut w=5e-06 l=1e-05 m=1.0
*************************************************************

********************* dut testbench 8_2 *********************
e_ds_8_2 d_8_2 0 v_sweep 0 1
v_gs_8_2 g_8_2 0 0.6
v_s_8_2 s_8_2 0 0
v_bs_8_2 b_8_2 0 -1.0
x_8_2 d_8_2 g_8_2 s_8_2 b_8_2 dut w=5e-06 l=1e-05 m=1.0
*************************************************************

********************* dut testbench 8_3 *********************
e_ds_8_3 d_8_3 0 v_sweep 0 1
v_gs_8_3 g_8_3 0 0.8
v_s_8_3 s_8_3 0 0
v_bs_8_3 b_8_3 0 -1.0
x_8_3 d_8_3 g_8_3 s_8_3 b_8_3 dut w=5e-06 l=1e-05 m=1.0
*************************************************************

********************* dut testbench 8_4 *********************
e_ds_8_4 d_8_4 0 v_sweep 0 1
v_gs_8_4 g_8_4 0 1.0
v_s_8_4 s_8_4 0 0
v_bs_8_4 b_8_4 0 -1.0
x_8_4 d_8_4 g_8_4 s_8_4 b_8_4 dut w=5e-06 l=1e-05 m=1.0
*************************************************************

********************* dut testbench 8_5 *********************
e_ds_8_5 d_8_5 0 v_sweep 0 1
v_gs_8_5 g_8_5 0 1.2
v_s_8_5 s_8_5 0 0
v_bs_8_5 b_8_5 0 -1.0
x_8_5 d_8_5 g_8_5 s_8_5 b_8_5 dut w=5e-06 l=1e-05 m=1.0
*************************************************************

********************* dut testbench 8_6 *********************
e_ds_8_6 d_8_6 0 v_sweep 0 1
v_gs_8_6 g_8_6 0 1.4
v_s_8_6 s_8_6 0 0
v_bs_8_6 b_8_6 0 -1.0
x_8_6 d_8_6 g_8_6 s_8_6 b_8_6 dut w=5e-06 l=1e-05 m=1.0
*************************************************************

********************* dut testbench 8_7 *********************
e_ds_8_7 d_8_7 0 v_sweep 0 1
v_gs_8_7 g_8_7 0 1.6
v_s_8_7 s_8_7 0 0
v_bs_8_7 b_8_7 0 -1.0
x_8_7 d_8_7 g_8_7 s_8_7 b_8_7 dut w=5e-06 l=1e-05 m=1.0
*************************************************************

********************* dut testbench 9_0 *********************
e_ds_9_0 d_9_0 0 v_sweep 0 1
v_gs_9_0 g_9_0 0 0.2
v_s_9_0 s_9_0 0 0
v_bs_9_0 b_9_0 0 0.0
x_9_0 d_9_0 g_9_0 s_9_0 b_9_0 dut w=5e-06 l=1e-05 m=1.0
*************************************************************

********************* dut testbench 9_1 *********************
e_ds_9_1 d_9_1 0 v_sweep 0 1
v_gs_9_1 g_9_1 0 0.4
v_s_9_1 s_9_1 0 0
v_bs_9_1 b_9_1 0 0.0
x_9_1 d_9_1 g_9_1 s_9_1 b_9_1 dut w=5e-06 l=1e-05 m=1.0
*************************************************************

********************* dut testbench 9_2 *********************
e_ds_9_2 d_9_2 0 v_sweep 0 1
v_gs_9_2 g_9_2 0 0.6
v_s_9_2 s_9_2 0 0
v_bs_9_2 b_9_2 0 0.0
x_9_2 d_9_2 g_9_2 s_9_2 b_9_2 dut w=5e-06 l=1e-05 m=1.0
*************************************************************

********************* dut testbench 9_3 *********************
e_ds_9_3 d_9_3 0 v_sweep 0 1
v_gs_9_3 g_9_3 0 0.8
v_s_9_3 s_9_3 0 0
v_bs_9_3 b_9_3 0 0.0
x_9_3 d_9_3 g_9_3 s_9_3 b_9_3 dut w=5e-06 l=1e-05 m=1.0
*************************************************************

********************* dut testbench 9_4 *********************
e_ds_9_4 d_9_4 0 v_sweep 0 1
v_gs_9_4 g_9_4 0 1.0
v_s_9_4 s_9_4 0 0
v_bs_9_4 b_9_4 0 0.0
x_9_4 d_9_4 g_9_4 s_9_4 b_9_4 dut w=5e-06 l=1e-05 m=1.0
*************************************************************

********************* dut testbench 9_5 *********************
e_ds_9_5 d_9_5 0 v_sweep 0 1
v_gs_9_5 g_9_5 0 1.2
v_s_9_5 s_9_5 0 0
v_bs_9_5 b_9_5 0 0.0
x_9_5 d_9_5 g_9_5 s_9_5 b_9_5 dut w=5e-06 l=1e-05 m=1.0
*************************************************************

********************* dut testbench 9_6 *********************
e_ds_9_6 d_9_6 0 v_sweep 0 1
v_gs_9_6 g_9_6 0 1.4
v_s_9_6 s_9_6 0 0
v_bs_9_6 b_9_6 0 0.0
x_9_6 d_9_6 g_9_6 s_9_6 b_9_6 dut w=5e-06 l=1e-05 m=1.0
*************************************************************

********************* dut testbench 9_7 *********************
e_ds_9_7 d_9_7 0 v_sweep 0 1
v_gs_9_7 g_9_7 0 1.6
v_s_9_7 s_9_7 0 0
v_bs_9_7 b_9_7 0 0.0
x_9_7 d_9_7 g_9_7 s_9_7 b_9_7 dut w=5e-06 l=1e-05 m=1.0
*************************************************************

** End testbenches

* Declare the v_sweep, which will change during the simulation.
v_sweep v_sweep 0 0

********** Start of control section **********
.control

** Model parameters start
alterparam dut a0 = 1.2937094785101237
alterparam dut a1 = 0.05826060817531292
alterparam dut a2 = 0.026730354585731336
alterparam dut acde = 1.5805741406051987
alterparam dut ags = 0.3932198666869464
alterparam dut bin_lketa = 0.31973124232025274
alterparam dut bin_pketa = 0.18478002691335282
alterparam dut bin_ppclm = 0.23780176048813403
alterparam dut bin_prdsw = 0.5951550158621742
alterparam dut bin_pvsat = 0.8574692428908665
alterparam dut bin_wk3 = 0.2421411353831801
alterparam dut bin_wk3b = 0.028308875677266476
alterparam dut bin_wketa = 0.7562953888804625
alterparam dut cf = 1.769400085651038e-10
alterparam dut cgdl = 4.795347286470063e-09
alterparam dut cgdo = 1.9975162424348913e-10
alterparam dut ckappas = 0.5653970630266125
alterparam dut clc = 1.3457691036133088e-07
alterparam dut cle = 0.7322389901062831
alterparam dut dlc = 6.310485566799817e-08
alterparam dut drout = 1.5693306119636736
alterparam dut dsub = 0.42233003224447696
alterparam dut dvt0 = 17.957674747171176
alterparam dut dvt0w = 4.531054095369372
alterparam dut dvt1 = 0.46740526280821393
alterparam dut dvt1w = 0.1475036306665623
alterparam dut dvt2 = 0.0728233833016646
alterparam dut dvt2w = 1*-0.01218516854474768
alterparam dut dwg = 3.748967820434991e-08
alterparam dut eta0 = 0.9345762627924593
alterparam dut etab = 1*-0.00626809330721545
alterparam dut k1 = 0.10663078325586373
alterparam dut k2 = 1*-0.0458587345589546
alterparam dut k3 = 1*-91.39661782652419
alterparam dut k3b = 1*-17.41366939134275
alterparam dut keta = 1*-0.006713715496573111
alterparam dut lint = 1*-5.970434844685687e-08
alterparam dut ll = 8.279525677688919e-15
alterparam dut lwl = 6.117649890059654e-20
alterparam dut moin = 24.231051232275735
alterparam dut ndep = 4.86887358207262e+17
alterparam dut nfactor = 1.5695452013811282
alterparam dut ngate = 3.5789746068387185e+19
alterparam dut noff = 3.4841259938475586
alterparam dut pclm = 0.003083215531148329
alterparam dut pdiblc1 = 2.669138492348154e-05
alterparam dut pdiblc2 = 1.2072327996842383e-05
alterparam dut pdiblcb = 1*-0.036336636210468676
alterparam dut pvag = 3.0762228417329345
alterparam dut rdsw = 2034.2561675611112
alterparam dut toxp = 5.642659142686204e-09
alterparam dut u0 = 679.4255759668404
alterparam dut ua = 6.729197645207437e-10
alterparam dut ub = 5.327313302391265e-19
alterparam dut uc = 1*-2.5941250697834373e-09
alterparam dut voff = 1*-0.0001402691997631489
alterparam dut voffcv = 0.2021492221573329
alterparam dut voffl = 1*-7.51625947112671e-08
alterparam dut vsat = 255706.13442882895
alterparam dut vth0 = 1*-1.3428046633626125
alterparam dut w0 = 2.5449708426009607e-06
alterparam dut wint = 8.188754579644564e-08
alterparam dut ww = 1*-8.134243872936293e-14
alterparam dut wwl = 1*-7.737740557973894e-20
alterparam dut xpart = 0.40841121564500116
reset
** Model parameters end

** Declare the vectors to save.
save v(d_0_2) v(d_1_1) v(d_3_3) v(d_0_0) i(v_s_7_1) i(v_s_8_3) i(v_s_0_1) i(v_s_7_4) i(v_s_5_0) i(v_s_5_7) i(v_s_3_1) i(v_s_8_2) v(d_0_7) v(d_0_4) i(v_s_7_6) i(v_s_4_5) i(v_s_3_0) v(d_5_1) i(v_s_1_7) v(d_0_5) i(v_s_2_7) i(v_s_5_3) v(d_8_1) i(v_s_4_2) v(d_7_3) i(v_s_7_0) i(v_s_5_2) v(d_7_2) v(d_8_5) v(d_6_2) v(d_2_1) i(v_s_7_3) i(v_s_6_3) i(v_s_3_5) v(d_8_6) i(v_s_2_1) i(v_s_2_2) v(d_3_2) v(d_3_1) i(v_s_8_1) i(v_s_7_7) i(v_s_8_5) v(d_7_5) i(v_s_7_5) i(v_s_6_4) i(v_s_3_4) i(v_s_3_2) v(d_3_4) v(d_3_5) i(v_s_0_0) i(v_s_9_4) v(d_9_7) i(v_s_6_7) v(d_2_7) i(v_s_9_6) v(d_9_0) v(d_6_0) v(d_5_3) i(v_s_3_6) i(v_s_9_7) v(d_2_4) v(d_8_7) i(v_s_9_2) i(v_s_3_7) v(d_5_4) i(v_s_2_5) v(d_1_0) i(v_s_0_6) i(v_s_0_7) i(v_s_2_3) v(d_7_1) i(v_s_4_4) v(d_5_7) v(d_4_6) i(v_s_6_2) v(d_3_6) i(v_s_8_0) v(d_9_1) i(v_s_5_1) v(d_4_1) v(d_6_4) i(v_s_4_7) v(d_1_2) v(d_5_0) i(v_s_9_0) i(v_s_4_0) v(d_3_0) v(d_6_3) i(v_s_1_1) i(v_s_0_3) i(v_s_5_6) v(d_4_5) v(d_4_2) v(d_2_5) v(d_5_5) i(v_s_1_0) i(v_s_4_3) i(v_s_9_3) v(d_1_3) v(d_6_7) v(d_2_0) i(v_s_2_6) i(v_s_3_3) i(v_s_0_4) v(d_1_5) i(v_s_8_7) i(v_s_9_5) v(d_2_6) v(d_0_1) i(v_s_1_2) i(v_s_0_5) i(v_s_5_5) v(d_0_3) v(d_8_0) v(d_7_4) v(d_7_7) v(d_9_3) v(d_6_1) v(d_2_3) v(d_4_4) i(v_s_6_0) i(v_s_8_6) v(d_4_7) v(d_8_4) v(d_2_2) v(d_7_0) v(d_1_7) v(d_9_5) i(v_s_6_6) v(d_6_6) i(v_s_4_6) v(d_9_6) v(d_9_4) i(v_s_1_3) v(d_4_0) v(d_3_7) i(v_s_7_2) v(d_8_2) v(d_6_5) i(v_s_6_5) v(d_9_2) i(v_s_0_2) i(v_s_8_4) v(d_0_6) i(v_s_5_4) i(v_s_9_1) v(d_5_2) v(d_5_6) i(v_s_1_5) i(v_s_2_4) i(v_s_6_1) v(d_7_6) v(d_1_6) i(v_s_2_0) i(v_s_4_1) v(d_8_3) i(v_s_1_6) v(d_4_3)

** Run the dc sweep analysis.
dc v_sweep 0.0 1.6 0.1

** Save the output to file.
set wr_vecnames
set wr_singlescale
wrdata /home/gazi/Desktop/Work/custom_packages/aivalanche/aivalanche_app/src/aivalanche_app/data_store/projects/project_1.gazi.5ce9039e-e488-419b-92e8-c95a713c4994/models/model_1.0e00713a-4f68-42d4-9653-2a40c98c558f/calibration_07_08_2024-19_13_31/simulation_files/dc_sweep_10.csv v(d_0_2) v(d_1_1) v(d_3_3) v(d_0_0) i(v_s_7_1) i(v_s_8_3) i(v_s_0_1) i(v_s_7_4) i(v_s_5_0) i(v_s_5_7) i(v_s_3_1) i(v_s_8_2) v(d_0_7) v(d_0_4) i(v_s_7_6) i(v_s_4_5) i(v_s_3_0) v(d_5_1) i(v_s_1_7) v(d_0_5) i(v_s_2_7) i(v_s_5_3) v(d_8_1) i(v_s_4_2) v(d_7_3) i(v_s_7_0) i(v_s_5_2) v(d_7_2) v(d_8_5) v(d_6_2) v(d_2_1) i(v_s_7_3) i(v_s_6_3) i(v_s_3_5) v(d_8_6) i(v_s_2_1) i(v_s_2_2) v(d_3_2) v(d_3_1) i(v_s_8_1) i(v_s_7_7) i(v_s_8_5) v(d_7_5) i(v_s_7_5) i(v_s_6_4) i(v_s_3_4) i(v_s_3_2) v(d_3_4) v(d_3_5) i(v_s_0_0) i(v_s_9_4) v(d_9_7) i(v_s_6_7) v(d_2_7) i(v_s_9_6) v(d_9_0) v(d_6_0) v(d_5_3) i(v_s_3_6) i(v_s_9_7) v(d_2_4) v(d_8_7) i(v_s_9_2) i(v_s_3_7) v(d_5_4) i(v_s_2_5) v(d_1_0) i(v_s_0_6) i(v_s_0_7) i(v_s_2_3) v(d_7_1) i(v_s_4_4) v(d_5_7) v(d_4_6) i(v_s_6_2) v(d_3_6) i(v_s_8_0) v(d_9_1) i(v_s_5_1) v(d_4_1) v(d_6_4) i(v_s_4_7) v(d_1_2) v(d_5_0) i(v_s_9_0) i(v_s_4_0) v(d_3_0) v(d_6_3) i(v_s_1_1) i(v_s_0_3) i(v_s_5_6) v(d_4_5) v(d_4_2) v(d_2_5) v(d_5_5) i(v_s_1_0) i(v_s_4_3) i(v_s_9_3) v(d_1_3) v(d_6_7) v(d_2_0) i(v_s_2_6) i(v_s_3_3) i(v_s_0_4) v(d_1_5) i(v_s_8_7) i(v_s_9_5) v(d_2_6) v(d_0_1) i(v_s_1_2) i(v_s_0_5) i(v_s_5_5) v(d_0_3) v(d_8_0) v(d_7_4) v(d_7_7) v(d_9_3) v(d_6_1) v(d_2_3) v(d_4_4) i(v_s_6_0) i(v_s_8_6) v(d_4_7) v(d_8_4) v(d_2_2) v(d_7_0) v(d_1_7) v(d_9_5) i(v_s_6_6) v(d_6_6) i(v_s_4_6) v(d_9_6) v(d_9_4) i(v_s_1_3) v(d_4_0) v(d_3_7) i(v_s_7_2) v(d_8_2) v(d_6_5) i(v_s_6_5) v(d_9_2) i(v_s_0_2) i(v_s_8_4) v(d_0_6) i(v_s_5_4) i(v_s_9_1) v(d_5_2) v(d_5_6) i(v_s_1_5) i(v_s_2_4) i(v_s_6_1) v(d_7_6) v(d_1_6) i(v_s_2_0) i(v_s_4_1) v(d_8_3) i(v_s_1_6) v(d_4_3)

.endc
********** End of control section **********

.end
