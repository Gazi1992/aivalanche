**********************************************************
* THIS FILE IS GENERATED BY AIVALANCHE
* FILE ID: 1
* SIMULATION TYPE: ac_point_dc_list
**********************************************************

* Define the temperature
.TEMP 25.0

* Include the dut file
.INCLUDE /home/gazi/Desktop/Work/custom_packages/aivalanche/aivalanche_app/src/aivalanche_app/data_store/projects/project_1.gazi.5ce9039e-e488-419b-92e8-c95a713c4994/common/model_files/dut.cir

** Start testbenches

********************* dut testbench 23_1 *********************
v_gs_ac_23_1 g_23_1 g_ac_23_1 DC 0 AC 1
e_gs_23_1 g_ac_23_1 0 v_sweep 0 1
v_ds_23_1 d_23_1 0 0.0
v_s_23_1 s_23_1 0 0
v_bs_23_1 b_23_1 0 1.0
x_23_1 d_23_1 g_23_1 s_23_1 b_23_1 dut w=5e-06 l=6e-06 m=1.0
*************************************************************

********************* dut testbench 23_2 *********************
v_gs_ac_23_2 g_23_2 g_ac_23_2 DC 0 AC 1
e_gs_23_2 g_ac_23_2 0 v_sweep 0 1
v_ds_23_2 d_23_2 0 0.0
v_s_23_2 s_23_2 0 0
v_bs_23_2 b_23_2 0 -1.0
x_23_2 d_23_2 g_23_2 s_23_2 b_23_2 dut w=5e-06 l=6e-06 m=1.0
*************************************************************

** End testbenches

* Declare the v_sweep, which will change during the simulation.
v_sweep v_sweep 0 0

********** Start of control section **********
.control

** Model parameters start
alterparam dut a0 = 0.9059857922420579
alterparam dut a1 = 0.09228821176714376
alterparam dut a2 = 0.15069469654892026
alterparam dut acde = 0.4831542604841188
alterparam dut ags = 0.3382785365835548
alterparam dut bin_lketa = 0.9902835181176363
alterparam dut bin_pketa = 0.5048009429524128
alterparam dut bin_ppclm = 0.7036640737455618
alterparam dut bin_prdsw = 0.16610791859304785
alterparam dut bin_pvsat = 0.8969209001822713
alterparam dut bin_wk3 = 0.4050135668931571
alterparam dut bin_wk3b = 0.07023942928784863
alterparam dut bin_wketa = 0.03920254109365952
alterparam dut cf = 1.3822757099732014e-10
alterparam dut cgdl = 3.971864522581234e-09
alterparam dut cgdo = 1.59502284654075e-11
alterparam dut ckappas = 8.38165924051763
alterparam dut clc = 7.051441928430551e-08
alterparam dut cle = 0.7108656931295612
alterparam dut dlc = 1*-1.3622822993834628e-08
alterparam dut drout = 1.0726449168890686
alterparam dut dsub = 0.4313278427117875
alterparam dut dvt0 = 18.10168185953436
alterparam dut dvt0w = 7.795232381680767
alterparam dut dvt1 = 1.2195515905891035
alterparam dut dvt1w = 6551895.305860748
alterparam dut dvt2 = 1*-0.11765354673933894
alterparam dut dvt2w = 1*-0.03560130658690107
alterparam dut dwg = 6.809179382871824e-08
alterparam dut eta0 = 0.37134932116203007
alterparam dut etab = 1*-0.11303632863820123
alterparam dut k1 = 1.1167290616450316
alterparam dut k2 = 0.046096373277688965
alterparam dut k3 = 52.61254940107588
alterparam dut k3b = 1*-7.925356233322699
alterparam dut keta = 1*-0.0035342459055456577
alterparam dut lint = 1*-9.859029385404123e-08
alterparam dut ll = 2.6235217530387784e-14
alterparam dut lwl = 1*-2.827035834995139e-20
alterparam dut moin = 16.51762877370289
alterparam dut ndep = 3.5588174499621693e+18
alterparam dut nfactor = 0.6897679378032957
alterparam dut ngate = 2.8268596520596518e+20
alterparam dut noff = 0.25654907954254347
alterparam dut pclm = 7.809434367822703e-08
alterparam dut pdiblc1 = 1.5671774827126032e-06
alterparam dut pdiblc2 = 9.536926163535512e-05
alterparam dut pdiblcb = 1*-0.8737041457489948
alterparam dut pvag = 0.9233996957832942
alterparam dut rdsw = 1553.4565495330464
alterparam dut toxp = 5.2548248357469155e-09
alterparam dut u0 = 26.10803759961999
alterparam dut ua = 3.553862723432093e-09
alterparam dut ub = 3.044563770670653e-20
alterparam dut uc = 1*-4.245289898637479e-10
alterparam dut voff = 1*-0.03462858924798773
alterparam dut voffcv = 1*-0.2678832045404002
alterparam dut voffl = 1*-9.543428359077884e-08
alterparam dut vsat = 79300.55083456374
alterparam dut vth0 = 1*-1.7899359758169582
alterparam dut w0 = 5.320013086380068e-11
alterparam dut wint = 3.5380620686354624e-08
alterparam dut ww = 1*-9.492117661630919e-14
alterparam dut wwl = 1*-5.703457652178616e-20
alterparam dut xpart = 0.7696893718255504
reset
** Model parameters end

** Declare the vectors to save.
save i(v_bs_23_2) i(v_ds_23_1) i(v_ds_23_2) i(v_s_23_1) i(v_bs_23_1) i(v_s_23_2)

** Write the header of the results file.
echo "vgs,cgg_23_2,cgg_23_1" > /home/gazi/Desktop/Work/custom_packages/aivalanche/aivalanche_app/src/aivalanche_app/data_store/projects/project_1.gazi.5ce9039e-e488-419b-92e8-c95a713c4994/models/model_1.0e00713a-4f68-42d4-9653-2a40c98c558f/calibration_08_08_2024-15_08_41/simulation_files/ac_point_dc_list_1.csv

** Start the simulation loop.
set values_list = ( -2.0 -1.9 -1.85 -1.8 -1.75 -1.7 -1.65 -1.6 -1.55 -1.5 -1.45 -1.4 -1.35 -1.3 -1.25 -1.2 -1.15 -1.1 -1.05 -1.0 -0.95 -0.9 -0.85 -0.8 -0.75 -0.7 -0.65 -0.6 -0.55 -0.5 -0.45 -0.4 -0.35 -0.3 -0.25 -0.2 -0.15 -0.1 -0.05 1.20737e-15 0.05 0.1 0.15 0.2 0.25 0.3 0.35 0.4 0.45 0.5 0.55 0.6 0.65 0.7 0.75 0.8 0.85 0.9 0.95 1.0 1.05 1.1 1.15 1.2 1.25 1.3 1.35 1.4 1.45 1.5 1.55 1.6 1.65 1.7 1.75 1.8 1.85 1.9 1.95 2.0 )
foreach val $values_list
    alter v_sweep $val
    ac lin 1 10000.0 10000.0

    let cgg_23_1 = (abs(imag(i(v_s_23_1))) + abs(imag(i(v_ds_23_1))) + abs(imag(i(v_bs_23_1))))/2*pi*10000.0
    let cgg_23_2 = (abs(imag(i(v_s_23_2))) + abs(imag(i(v_ds_23_2))) + abs(imag(i(v_bs_23_2))))/2*pi*10000.0

    echo "$val,$&cgg_23_2,$&cgg_23_1" >> /home/gazi/Desktop/Work/custom_packages/aivalanche/aivalanche_app/src/aivalanche_app/data_store/projects/project_1.gazi.5ce9039e-e488-419b-92e8-c95a713c4994/models/model_1.0e00713a-4f68-42d4-9653-2a40c98c558f/calibration_08_08_2024-15_08_41/simulation_files/ac_point_dc_list_1.csv
end

.endc
********** End of control section **********

.end
