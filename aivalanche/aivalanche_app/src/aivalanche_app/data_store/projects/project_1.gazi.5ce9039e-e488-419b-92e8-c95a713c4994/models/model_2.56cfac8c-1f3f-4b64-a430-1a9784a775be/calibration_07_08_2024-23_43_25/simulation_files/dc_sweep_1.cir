**********************************************************
* THIS FILE IS GENERATED BY AIVALANCHE
* FILE ID: 1
* SIMULATION TYPE: dc_sweep
**********************************************************

* Define the temperature
.TEMP 40.0

* Include the dut file
.INCLUDE /home/gazi/Desktop/Work/custom_packages/aivalanche/aivalanche_app/src/aivalanche_app/data_store/projects/project_1.gazi.5ce9039e-e488-419b-92e8-c95a713c4994/common/model_files/dut_1.cir

** Start testbenches

********************* dut testbench 0_1 *********************
e_v_0_1 p_0_1 0 v_sweep 0 1
v_meas_0_1 n_0_1 0 0
x_0_1 p_0_1 n_0_1 dut area=2e-06 m=1.0
*************************************************************

** End testbenches

* Declare the v_sweep, which will change during the simulation.
v_sweep v_sweep 0 0

********** Start of control section **********
.control

** Model parameters start
alterparam dut bv = 1848978534.6729538
alterparam dut ibv = 1.7327475631467313e-06
alterparam dut ikf = 8.799655786368521e-05
alterparam dut ikr = 3.4373379981586503e-07
alterparam dut is = 6.222588129772857e-14
alterparam dut jsw = 8.329244610478777e-14
alterparam dut n = 1.7973493708447
alterparam dut nbv = 0.14934534468690397
alterparam dut rs = 1.0136974374707657e-06
alterparam dut trs1 = 0.004285067711045861
alterparam dut trs2 = 0.00048021539435252463
reset
** Model parameters end

** Declare the vectors to save.
save i(v_meas_0_1) v(p_0_1)

** Run the dc sweep analysis.
dc v_sweep -0.2 3.5 0.1

** Save the output to file.
set wr_vecnames
set wr_singlescale
wrdata /home/gazi/Desktop/Work/custom_packages/aivalanche/aivalanche_app/src/aivalanche_app/data_store/projects/project_1.gazi.5ce9039e-e488-419b-92e8-c95a713c4994/models/model_2.56cfac8c-1f3f-4b64-a430-1a9784a775be/calibration_07_08_2024-23_43_25/simulation_files/dc_sweep_1.csv i(v_meas_0_1) v(p_0_1)

.endc
********** End of control section **********

.end
