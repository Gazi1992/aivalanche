**********************************************************
* THIS FILE IS GENERATED BY AIVALANCHE
* FILE ID: 0
* SIMULATION TYPE: dc_sweep
**********************************************************

* Define the temperature
.TEMP 27.0

* Include the dut file
.INCLUDE /home/gazi/Desktop/Work/custom_packages/aivalanche/aivalanche_app/src/aivalanche_app/data_store/projects/project_1.gazi.5ce9039e-e488-419b-92e8-c95a713c4994/common/model_files/dut_1.cir

** Start testbenches

********************* dut testbench 0_0 *********************
e_v_0_0 p_0_0 0 v_sweep 0 1
v_meas_0_0 n_0_0 0 0
x_0_0 p_0_0 n_0_0 dut area=2e-06 m=1.0
*************************************************************

** End testbenches

* Declare the v_sweep, which will change during the simulation.
v_sweep v_sweep 0 0

********** Start of control section **********
.control

** Model parameters start
alterparam dut bv = 34365849351.79083
alterparam dut ibv = 3.1814822291382064e-05
alterparam dut ikf = 2.3447512583797142e-05
alterparam dut ikr = 0.0008933667152137665
alterparam dut is = 8.450793824454346e-18
alterparam dut jsw = 4.329859884033616e-17
alterparam dut n = 1.1938113545431062
alterparam dut nbv = 1.4159524546147564
alterparam dut rs = 1.0056397935667576e-06
alterparam dut trs1 = 0.004700680711617223
alterparam dut trs2 = 0.0005132706754546442
reset
** Model parameters end

** Declare the vectors to save.
save v(p_0_0) i(v_meas_0_0)

** Run the dc sweep analysis.
dc v_sweep -0.2 3.5 0.1

** Save the output to file.
set wr_vecnames
set wr_singlescale
wrdata /home/gazi/Desktop/Work/custom_packages/aivalanche/aivalanche_app/src/aivalanche_app/data_store/projects/project_1.gazi.5ce9039e-e488-419b-92e8-c95a713c4994/models/model_2.56cfac8c-1f3f-4b64-a430-1a9784a775be/calibration_27_07_2024-00_40_53/simulation_files/dc_sweep_0.csv v(p_0_0) i(v_meas_0_0)

.endc
********** End of control section **********

.end
