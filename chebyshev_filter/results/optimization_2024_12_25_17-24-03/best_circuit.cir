* 7th Order Chebyshev Filter with simplified op-amp
.subckt OPAMP1 inp inn vdd vss out
.param gain=9.792055089902487 rout=50
E1 out1 0 inp inn {gain}
Rout out1 out {rout}
.ends

* Input source
V1 in 0 AC 1
Vbias vbias 0 DC 2.5
Vpos vcc 0 DC 15
Vneg vee 0 DC -15

* First Stage
X11 2 1 vcc vee 3 OPAMP1
R14 in 2 120744.65415519226
R11 vbias 1 37264.417953171396
C11 vbias 3 1.3054432760837452e-09
R13 3 4 11869.003272284013
R12 0 4 46125.46386273861
X12 5 4 vcc vee 6 OPAMP1
C12 0 5 3.9150320141042484e-09
R15 6 7 6207.717644059814
X13 out1 7 vcc vee out1 OPAMP1
R16 vcc 7 9570.256796664666

* Second Stage
X21 9 8 vcc vee 10 OPAMP1
R24 out1 9 21755.845800824194
R21 vbias 8 63565.6801877765
C21 vbias 10 1.6100971423651165e-09
R23 10 11 10701.554642190817
R22 0 11 28190.31295353098
X22 12 11 vcc vee 13 OPAMP1
C22 0 12 1.536761967087721e-09
R25 13 14 4419.046228680442
X23 out2 14 vcc vee out2 OPAMP1
R26 vcc 14 63330.36713755461

* Third Stage
X31 16 15 vcc vee 17 OPAMP1
R34 out2 16 28920.348694523378
R31 vbias 15 127147.89268400302
C31 vbias 17 3.80528862250658e-09
R33 17 18 70813.59528278651
R32 0 18 96854.08606391051
X32 19 18 vcc vee 20 OPAMP1
C32 0 19 2.2706182521167606e-09
R35 20 21 15580.452131554794
X33 out3 21 vcc vee out3 OPAMP1
R36 vcc 21 20075.279659986576

* Output Stage
X41 output 22 vcc vee output OPAMP1
R41 out3 22 98880.20862821605
R42 0 22 94849.92893612805
C41 0 22 9.947664002054265e-09

* Analysis commands
.control
set units=degrees
ac dec 100 1 1MEG
wrdata filter_response.txt v(output)
quit
.endc
.end
